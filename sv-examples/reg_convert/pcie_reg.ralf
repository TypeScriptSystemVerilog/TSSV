block control {
    bytes 4;
    register PCIEPHY_CTRL_0 @0x0 {
    bytes 4;
        field pipe_lane0_tx2rx_loopbk {
            bits 1;
            reset 0x0;
            access rw;
        }
        field pipe_lane1_tx2rx_loopbk @ 1 {
            bits 1;
            reset 0x0;
            access rw;
        }
        field pipe_lane2_tx2rx_loopbk @ 2 {
            bits 1;
            reset 0x0;
            access rw;
        }
        field pipe_lane3_tx2rx_loopbk @ 3 {
            bits 1;
            reset 0x0;
            access rw;
        }
        field pipe_lane4_tx2rx_loopbk @ 4 {
            bits 1;
            reset 0x0;
            access rw;
        }
        field pipe_lane5_tx2rx_loopbk @ 5 {
            bits 1;
            reset 0x0;
            access rw;
        }
        field pipe_lane6_tx2rx_loopbk @ 6 {
            bits 1;
            reset 0x0;
            access rw;
        }
        field pipe_lane7_tx2rx_loopbk @ 7 {
            bits 1;
            reset 0x0;
            access rw;
        }
        field pipe_lane8_tx2rx_loopbk @ 8 {
            bits 1;
            reset 0x0;
            access rw;
        }
        field pipe_lane9_tx2rx_loopbk @ 9 {
            bits 1;
            reset 0x0;
            access rw;
        }
        field pipe_lane10_tx2rx_loopbk @ 10 {
            bits 1;
            reset 0x0;
            access rw;
        }
        field pipe_lane11_tx2rx_loopbk @ 11 {
            bits 1;
            reset 0x0;
            access rw;
        }
        field pipe_lane12_tx2rx_loopbk @ 12 {
            bits 1;
            reset 0x0;
            access rw;
        }
        field pipe_lane13_tx2rx_loopbk @ 13 {
            bits 1;
            reset 0x0;
            access rw;
        }
        field pipe_lane14_tx2rx_loopbk @ 14 {
            bits 1;
            reset 0x0;
            access rw;
        }
        field pipe_lane15_tx2rx_loopbk @ 15 {
            bits 1;
            reset 0x0;
            access rw;
        }
        field pipe_lane0_ropll_freq_mode @ 16 {
            bits 1;
            reset 0x0;
            access rw;
        }
        field pipe_lane1_ropll_freq_mode @ 17 {
            bits 1;
            reset 0x0;
            access rw;
        }
        field pipe_lane2_ropll_freq_mode @ 18 {
            bits 1;
            reset 0x0;
            access rw;
        }
        field pipe_lane3_ropll_freq_mode @ 19 {
            bits 1;
            reset 0x0;
            access rw;
        }
        field pipe_lane4_ropll_freq_mode @ 20 {
            bits 1;
            reset 0x0;
            access rw;
        }
        field pipe_lane5_ropll_freq_mode @ 21 {
            bits 1;
            reset 0x0;
            access rw;
        }
        field pipe_lane6_ropll_freq_mode @ 22 {
            bits 1;
            reset 0x0;
            access rw;
        }
        field pipe_lane7_ropll_freq_mode @ 23 {
            bits 1;
            reset 0x0;
            access rw;
        }
        field pipe_lane8_ropll_freq_mode @ 24 {
            bits 1;
            reset 0x0;
            access rw;
        }
        field pipe_lane9_ropll_freq_mode @ 25 {
            bits 1;
            reset 0x0;
            access rw;
        }
        field pipe_lane10_ropll_freq_mode @ 26 {
            bits 1;
            reset 0x0;
            access rw;
        }
        field pipe_lane11_ropll_freq_mode @ 27 {
            bits 1;
            reset 0x0;
            access rw;
        }
        field pipe_lane12_ropll_freq_mode @ 28 {
            bits 1;
            reset 0x0;
            access rw;
        }
        field pipe_lane13_ropll_freq_mode @ 29 {
            bits 1;
            reset 0x0;
            access rw;
        }
        field pipe_lane14_ropll_freq_mode @ 30 {
            bits 1;
            reset 0x0;
            access rw;
        }
        field pipe_lane15_ropll_freq_mode @ 31 {
            bits 1;
            reset 0x0;
            access rw;
        }
    }
    register PCIEPHY_CTRL_1 @0x4 {
    bytes 4;
        field pipe_rx0_termination {
            bits 1;
            reset 0x1;
            access rw;
        }
        field pipe_rx1_termination @ 1 {
            bits 1;
            reset 0x1;
            access rw;
        }
        field pipe_rx2_termination @ 2 {
            bits 1;
            reset 0x1;
            access rw;
        }
        field pipe_rx3_termination @ 3 {
            bits 1;
            reset 0x1;
            access rw;
        }
        field pipe_rx4_termination @ 4 {
            bits 1;
            reset 0x1;
            access rw;
        }
        field pipe_rx5_termination @ 5 {
            bits 1;
            reset 0x1;
            access rw;
        }
        field pipe_rx6_termination @ 6 {
            bits 1;
            reset 0x1;
            access rw;
        }
        field pipe_rx7_termination @ 7 {
            bits 1;
            reset 0x1;
            access rw;
        }
        field pipe_rx8_termination @ 8 {
            bits 1;
            reset 0x1;
            access rw;
        }
        field pipe_rx9_termination @ 9 {
            bits 1;
            reset 0x1;
            access rw;
        }
        field pipe_rx10_termination @ 10 {
            bits 1;
            reset 0x1;
            access rw;
        }
        field pipe_rx11_termination @ 11 {
            bits 1;
            reset 0x1;
            access rw;
        }
        field pipe_rx12_termination @ 12 {
            bits 1;
            reset 0x1;
            access rw;
        }
        field pipe_rx13_termination @ 13 {
            bits 1;
            reset 0x1;
            access rw;
        }
        field pipe_rx14_termination @ 14 {
            bits 1;
            reset 0x1;
            access rw;
        }
        field pipe_rx15_termination @ 15 {
            bits 1;
            reset 0x1;
            access rw;
        }
        field pipe_rx0_es_mode @ 16 {
            bits 1;
            reset 0x0;
            access rw;
        }
        field pipe_rx1_es_mode @ 17 {
            bits 1;
            reset 0x0;
            access rw;
        }
        field pipe_rx2_es_mode @ 18 {
            bits 1;
            reset 0x0;
            access rw;
        }
        field pipe_rx3_es_mode @ 19 {
            bits 1;
            reset 0x0;
            access rw;
        }
        field pipe_rx4_es_mode @ 20 {
            bits 1;
            reset 0x0;
            access rw;
        }
        field pipe_rx5_es_mode @ 21 {
            bits 1;
            reset 0x0;
            access rw;
        }
        field pipe_rx6_es_mode @ 22 {
            bits 1;
            reset 0x0;
            access rw;
        }
        field pipe_rx7_es_mode @ 23 {
            bits 1;
            reset 0x0;
            access rw;
        }
        field pipe_rx8_es_mode @ 24 {
            bits 1;
            reset 0x0;
            access rw;
        }
        field pipe_rx9_es_mode @ 25 {
            bits 1;
            reset 0x0;
            access rw;
        }
        field pipe_rx10_es_mode @ 26 {
            bits 1;
            reset 0x0;
            access rw;
        }
        field pipe_rx11_es_mode @ 27 {
            bits 1;
            reset 0x0;
            access rw;
        }
        field pipe_rx12_es_mode @ 28 {
            bits 1;
            reset 0x0;
            access rw;
        }
        field pipe_rx13_es_mode @ 29 {
            bits 1;
            reset 0x0;
            access rw;
        }
        field pipe_rx14_es_mode @ 30 {
            bits 1;
            reset 0x0;
            access rw;
        }
        field pipe_rx15_es_mode @ 31 {
            bits 1;
            reset 0x0;
            access rw;
        }
    }
    register PCIEPHY_CTRL_2 @0x8 {
    bytes 4;
        field pipe_lane0_databuswidth {
            bits 2;
            reset 0x0;
            access ro;
        }
        field pipe_lane1_databuswidth @ 2 {
            bits 2;
            reset 0x0;
            access ro;
        }
        field pipe_lane2_databuswidth @ 4 {
            bits 2;
            reset 0x0;
            access ro;
        }
        field pipe_lane3_databuswidth @ 6 {
            bits 2;
            reset 0x0;
            access ro;
        }
        field pipe_lane4_databuswidth @ 8 {
            bits 2;
            reset 0x0;
            access ro;
        }
        field pipe_lane5_databuswidth @ 10 {
            bits 2;
            reset 0x0;
            access ro;
        }
        field pipe_lane6_databuswidth @ 12 {
            bits 2;
            reset 0x0;
            access ro;
        }
        field pipe_lane7_databuswidth @ 14 {
            bits 2;
            reset 0x0;
            access ro;
        }
        field pipe_lane8_databuswidth @ 16 {
            bits 2;
            reset 0x0;
            access ro;
        }
        field pipe_lane9_databuswidth @ 18 {
            bits 2;
            reset 0x0;
            access ro;
        }
        field pipe_lane10_databuswidth @ 20 {
            bits 2;
            reset 0x0;
            access ro;
        }
        field pipe_lane11_databuswidth @ 22 {
            bits 2;
            reset 0x0;
            access ro;
        }
        field pipe_lane12_databuswidth @ 24 {
            bits 2;
            reset 0x0;
            access ro;
        }
        field pipe_lane13_databuswidth @ 26 {
            bits 2;
            reset 0x0;
            access ro;
        }
        field pipe_lane14_databuswidth @ 28 {
            bits 2;
            reset 0x0;
            access ro;
        }
        field pipe_lane15_databuswidth @ 30 {
            bits 2;
            reset 0x0;
            access ro;
        }
    }
    register PCIEPHY_CTRL_3 @0xC {
    bytes 4;
        field max_pclk_div_ratio_g1 {
            bits 5;
            reset 0x8;
            access rw;
        }
        field max_pclk_div_ratio_g2 @ 5 {
            bits 5;
            reset 0x4;
            access rw;
        }
        field max_pclk_div_ratio_g3 @ 10 {
            bits 5;
            reset 0x4;
            access rw;
        }
        field max_pclk_div_ratio_g4 @ 15 {
            bits 5;
            reset 0x2;
            access rw;
        }
        field max_pclk_div_ratio_g5 @ 20 {
            bits 5;
            reset 0x1;
            access rw;
        }
        field pipe_lane_cmn_refclk_mode @ 25 {
            bits 1;
            reset 0x1;
            access rw;
        }
    }
    register PCIEPHY_CTRL_4 @0x10 {
    bytes 4;
        field reserved {
            bits 1;
            reset 0x0;
            access rw;
        }
        field reserved @ 1 {
            bits 1;
            reset 0x0;
            access rw;
        }
        field phy0_cr_para_sel @ 2 {
            bits 1;
            reset 0x1;
            access rw;
        }
        field reserved @ 3 {
            bits 1;
            reset 0x0;
            access rw;
        }
        field phy0_mplla_force_en @ 4 {
            bits 1;
            reset 0x0;
            access rw;
        }
        field phy0_mplla_short_lock_en @ 5 {
            bits 1;
            reset 0x0;
            access rw;
        }
        field phy0_mplla_ssc_en @ 6 {
            bits 1;
            reset 0x0;
            access rw;
        }
        field reserved @ 7 {
            bits 1;
            reset 0x0;
            access rw;
        }
        field phy0_mplla_word_clk_en @ 8 {
            bits 1;
            reset 0x1;
            access rw;
        }
        field reserved @ 9 {
            bits 1;
            reset 0x0;
            access rw;
        }
        field phy0_mpllb_force_en @ 10 {
            bits 1;
            reset 0x0;
            access rw;
        }
        field phy0_mpllb_short_lock_en @ 11 {
            bits 1;
            reset 0x0;
            access rw;
        }
        field phy0_mpllb_ssc_en @ 12 {
            bits 1;
            reset 0x0;
            access rw;
        }
        field reserved @ 13 {
            bits 1;
            reset 0x0;
            access rw;
        }
        field phy0_mpllb_word_clk_en @ 14 {
            bits 1;
            reset 0x1;
            access rw;
        }
        field phy0_refa_lane_clk_en @ 15 {
            bits 1;
            reset 0x1;
            access rw;
        }
        field phy0_refb_lane_clk_en @ 16 {
            bits 1;
            reset 0x1;
            access rw;
        }
        field phy0_ref_repeat_clk_en @ 17 {
            bits 1;
            reset 0x1;
            access rw;
        }
        field phy0_ref_repeat_clk_sel @ 18 {
            bits 2;
            reset 0x1;
            access rw;
        }
        field phy0_refa_clk_sel @ 20 {
            bits 2;
            reset 0x1;
            access rw;
        }
        field phy0_refa_clkdet_en @ 22 {
            bits 1;
            reset 0x0;
            access rw;
        }
        field reserved @ 23 {
            bits 1;
            reset 0x0;
            access rw;
        }
        field phy0_refb_clk_sel @ 24 {
            bits 2;
            reset 0x1;
            access rw;
        }
        field phy0_refb_clkdet_en @ 26 {
            bits 1;
            reset 0x0;
            access rw;
        }
        field reserved @ 27 {
            bits 1;
            reset 0x0;
            access rw;
        }
        field phy0_fw_clk_range @ 28 {
            bits 4;
            reset 0x3;
            access rw;
        }
    }
    register PCIEPHY_CTRL_5 @0x14 {
    bytes 4;
        field phy0_rx_term_offset {
            bits 5;
            reset 0x0;
            access rw;
        }
        field phy0_txdn_term_offset @ 5 {
            bits 9;
            reset 0x0;
            access rw;
        }
        field phy0_txup_term_offset @ 14 {
            bits 9;
            reset 0x0;
            access rw;
        }
        field phy0_sram_bootload_bypass @ 23 {
            bits 1;
            reset 0x1;
            access rw;
        }
        field phy0_sram_bypass @ 24 {
            bits 1;
            reset 0x1;
            access rw;
        }
        field phy0_sram_ecc_en @ 25 {
            bits 1;
            reset 0x0;
            access rw;
        }
        field phy0_sram_ext_ld_done @ 26 {
            bits 1;
            reset 0x0;
            access rw;
        }
        field reserved @ 27 {
            bits 1;
            reset 0x0;
            access rw;
        }
        field phy0_refa_clk_div2_en @ 28 {
            bits 1;
            reset 0x0;
            access rw;
        }
        field phy0_refa_raw_clk_div2_en @ 29 {
            bits 1;
            reset 0x0;
            access rw;
        }
        field phy0_refb_clk_div2_en @ 30 {
            bits 1;
            reset 0x0;
            access rw;
        }
        field phy0_refb_raw_clk_div2_en @ 31 {
            bits 1;
            reset 0x0;
            access rw;
        }
    }
    register PCIEPHY_CTRL_6 @0x18 {
    bytes 4;
        field phy0_refa_range {
            bits 4;
            reset 0x3;
            access rw;
        }
        field phy0_refb_range @ 4 {
            bits 4;
            reset 0x3;
            access rw;
        }
        field phy0_sup_misc @ 7 {
            bits 24;
            reset 0x0;
            access rw;
        }
    }
    register PCIEPHY_CTRL_7 @0x1C {
    bytes 4;
        field reserved {
            bits 1;
            reset 0x0;
            access rw;
        }
        field reserved @ 1 {
            bits 1;
            reset 0x0;
            access rw;
        }
        field phy1_cr_para_sel @ 2 {
            bits 1;
            reset 0x1;
            access rw;
        }
        field reserved @ 3 {
            bits 1;
            reset 0x0;
            access rw;
        }
        field phy1_mplla_force_en @ 4 {
            bits 1;
            reset 0x0;
            access rw;
        }
        field phy1_mplla_short_lock_en @ 5 {
            bits 1;
            reset 0x0;
            access rw;
        }
        field phy1_mplla_ssc_en @ 6 {
            bits 1;
            reset 0x0;
            access rw;
        }
        field reserved @ 7 {
            bits 1;
            reset 0x0;
            access rw;
        }
        field phy1_mplla_word_clk_en @ 8 {
            bits 1;
            reset 0x1;
            access rw;
        }
        field reserved @ 9 {
            bits 1;
            reset 0x0;
            access rw;
        }
        field phy1_mpllb_force_en @ 10 {
            bits 1;
            reset 0x0;
            access rw;
        }
        field phy1_mpllb_short_lock_en @ 11 {
            bits 1;
            reset 0x0;
            access rw;
        }
        field phy1_mpllb_ssc_en @ 12 {
            bits 1;
            reset 0x0;
            access rw;
        }
        field reserved @ 13 {
            bits 1;
            reset 0x0;
            access rw;
        }
        field phy1_mpllb_word_clk_en @ 14 {
            bits 1;
            reset 0x1;
            access rw;
        }
        field phy1_refa_lane_clk_en @ 15 {
            bits 1;
            reset 0x1;
            access rw;
        }
        field phy1_refb_lane_clk_en @ 16 {
            bits 1;
            reset 0x1;
            access rw;
        }
        field phy1_ref_repeat_clk_en @ 17 {
            bits 1;
            reset 0x1;
            access rw;
        }
        field phy1_ref_repeat_clk_sel @ 18 {
            bits 2;
            reset 0x1;
            access rw;
        }
        field phy1_refa_clk_sel @ 20 {
            bits 2;
            reset 0x1;
            access rw;
        }
        field phy1_refa_clkdet_en @ 22 {
            bits 1;
            reset 0x0;
            access rw;
        }
        field reserved @ 23 {
            bits 1;
            reset 0x0;
            access rw;
        }
        field phy1_refb_clk_sel @ 24 {
            bits 2;
            reset 0x1;
            access rw;
        }
        field phy1_refb_clkdet_en @ 26 {
            bits 1;
            reset 0x0;
            access rw;
        }
        field reserved @ 27 {
            bits 1;
            reset 0x0;
            access rw;
        }
        field phy1_fw_clk_range @ 28 {
            bits 4;
            reset 0x3;
            access rw;
        }
    }
    register PCIEPHY_CTRL_8 @0x20 {
    bytes 4;
        field phy1_rx_term_offset {
            bits 5;
            reset 0x0;
            access rw;
        }
        field phy1_txdn_term_offset @ 5 {
            bits 9;
            reset 0x0;
            access rw;
        }
        field phy1_txup_term_offset @ 14 {
            bits 9;
            reset 0x0;
            access rw;
        }
        field phy1_sram_bootload_bypass @ 23 {
            bits 1;
            reset 0x1;
            access rw;
        }
        field phy1_sram_bypass @ 24 {
            bits 1;
            reset 0x1;
            access rw;
        }
        field phy1_sram_ecc_en @ 25 {
            bits 1;
            reset 0x0;
            access rw;
        }
        field phy1_sram_ext_ld_done @ 26 {
            bits 1;
            reset 0x0;
            access rw;
        }
        field reserved @ 27 {
            bits 1;
            reset 0x0;
            access rw;
        }
        field phy1_refa_clk_div2_en @ 28 {
            bits 1;
            reset 0x0;
            access rw;
        }
        field phy1_refa_raw_clk_div2_en @ 29 {
            bits 1;
            reset 0x0;
            access rw;
        }
        field phy1_refb_clk_div2_en @ 30 {
            bits 1;
            reset 0x0;
            access rw;
        }
        field phy1_refb_raw_clk_div2_en @ 31 {
            bits 1;
            reset 0x0;
            access rw;
        }
    }
    register PCIEPHY_CTRL_9 @0x24 {
    bytes 4;
        field phy1_refa_range {
            bits 4;
            reset 0x3;
            access rw;
        }
        field phy1_refb_range @ 4 {
            bits 4;
            reset 0x3;
            access rw;
        }
        field phy1_sup_misc @ 7 {
            bits 24;
            reset 0x0;
            access rw;
        }
    }
    register PCIEPHY_CTRL_10 @0x28 {
    bytes 4;
        field reserved {
            bits 1;
            reset 0x0;
            access rw;
        }
        field reserved @ 1 {
            bits 1;
            reset 0x0;
            access rw;
        }
        field phy2_cr_para_sel @ 2 {
            bits 1;
            reset 0x1;
            access rw;
        }
        field reserved @ 3 {
            bits 1;
            reset 0x0;
            access rw;
        }
        field phy2_mplla_force_en @ 4 {
            bits 1;
            reset 0x0;
            access rw;
        }
        field phy2_mplla_short_lock_en @ 5 {
            bits 1;
            reset 0x0;
            access rw;
        }
        field phy2_mplla_ssc_en @ 6 {
            bits 1;
            reset 0x0;
            access rw;
        }
        field reserved @ 7 {
            bits 1;
            reset 0x0;
            access rw;
        }
        field phy2_mplla_word_clk_en @ 8 {
            bits 1;
            reset 0x1;
            access rw;
        }
        field reserved @ 9 {
            bits 1;
            reset 0x0;
            access rw;
        }
        field phy2_mpllb_force_en @ 10 {
            bits 1;
            reset 0x0;
            access rw;
        }
        field phy2_mpllb_short_lock_en @ 11 {
            bits 1;
            reset 0x0;
            access rw;
        }
        field phy2_mpllb_ssc_en @ 12 {
            bits 1;
            reset 0x0;
            access rw;
        }
        field reserved @ 13 {
            bits 1;
            reset 0x0;
            access rw;
        }
        field phy2_mpllb_word_clk_en @ 14 {
            bits 1;
            reset 0x1;
            access rw;
        }
        field phy2_refa_lane_clk_en @ 15 {
            bits 1;
            reset 0x1;
            access rw;
        }
        field phy2_refb_lane_clk_en @ 16 {
            bits 1;
            reset 0x1;
            access rw;
        }
        field phy2_ref_repeat_clk_en @ 17 {
            bits 1;
            reset 0x1;
            access rw;
        }
        field phy2_ref_repeat_clk_sel @ 18 {
            bits 2;
            reset 0x1;
            access rw;
        }
        field phy2_refa_clk_sel @ 20 {
            bits 2;
            reset 0x1;
            access rw;
        }
        field phy2_refa_clkdet_en @ 22 {
            bits 1;
            reset 0x0;
            access rw;
        }
        field reserved @ 23 {
            bits 1;
            reset 0x0;
            access rw;
        }
        field phy2_refb_clk_sel @ 24 {
            bits 2;
            reset 0x1;
            access rw;
        }
        field phy2_refb_clkdet_en @ 26 {
            bits 1;
            reset 0x0;
            access rw;
        }
        field reserved @ 27 {
            bits 1;
            reset 0x0;
            access rw;
        }
        field phy2_fw_clk_range @ 28 {
            bits 4;
            reset 0x3;
            access rw;
        }
    }
    register PCIEPHY_CTRL_11 @0x2C {
    bytes 4;
        field phy2_rx_term_offset {
            bits 5;
            reset 0x0;
            access rw;
        }
        field phy2_txdn_term_offset @ 5 {
            bits 9;
            reset 0x0;
            access rw;
        }
        field phy2_txup_term_offset @ 14 {
            bits 9;
            reset 0x0;
            access rw;
        }
        field phy2_sram_bootload_bypass @ 23 {
            bits 1;
            reset 0x1;
            access rw;
        }
        field phy2_sram_bypass @ 24 {
            bits 1;
            reset 0x1;
            access rw;
        }
        field phy2_sram_ecc_en @ 25 {
            bits 1;
            reset 0x0;
            access rw;
        }
        field phy2_sram_ext_ld_done @ 26 {
            bits 1;
            reset 0x0;
            access rw;
        }
        field reserved @ 27 {
            bits 1;
            reset 0x0;
            access rw;
        }
        field phy2_refa_clk_div2_en @ 28 {
            bits 1;
            reset 0x0;
            access rw;
        }
        field phy2_refa_raw_clk_div2_en @ 29 {
            bits 1;
            reset 0x0;
            access rw;
        }
        field phy2_refb_clk_div2_en @ 30 {
            bits 1;
            reset 0x0;
            access rw;
        }
        field phy2_refb_raw_clk_div2_en @ 31 {
            bits 1;
            reset 0x0;
            access rw;
        }
    }
    register PCIEPHY_CTRL_12 @0x30 {
    bytes 4;
        field phy2_refa_range {
            bits 4;
            reset 0x3;
            access rw;
        }
        field phy2_refb_range @ 4 {
            bits 4;
            reset 0x3;
            access rw;
        }
        field phy2_sup_misc @ 7 {
            bits 24;
            reset 0x0;
            access rw;
        }
    }
    register PCIEPHY_CTRL_13 @0x34 {
    bytes 4;
        field reserved {
            bits 1;
            reset 0x0;
            access rw;
        }
        field reserved @ 1 {
            bits 1;
            reset 0x0;
            access rw;
        }
        field phy3_cr_para_sel @ 2 {
            bits 1;
            reset 0x1;
            access rw;
        }
        field reserved @ 3 {
            bits 1;
            reset 0x0;
            access rw;
        }
        field phy3_mplla_force_en @ 4 {
            bits 1;
            reset 0x0;
            access rw;
        }
        field phy3_mplla_short_lock_en @ 5 {
            bits 1;
            reset 0x0;
            access rw;
        }
        field phy3_mplla_ssc_en @ 6 {
            bits 1;
            reset 0x0;
            access rw;
        }
        field reserved @ 7 {
            bits 1;
            reset 0x0;
            access rw;
        }
        field phy3_mplla_word_clk_en @ 8 {
            bits 1;
            reset 0x1;
            access rw;
        }
        field reserved @ 9 {
            bits 1;
            reset 0x0;
            access rw;
        }
        field phy3_mpllb_force_en @ 10 {
            bits 1;
            reset 0x0;
            access rw;
        }
        field phy3_mpllb_short_lock_en @ 11 {
            bits 1;
            reset 0x0;
            access rw;
        }
        field phy3_mpllb_ssc_en @ 12 {
            bits 1;
            reset 0x0;
            access rw;
        }
        field reserved @ 13 {
            bits 1;
            reset 0x0;
            access rw;
        }
        field phy3_mpllb_word_clk_en @ 14 {
            bits 1;
            reset 0x1;
            access rw;
        }
        field phy3_refa_lane_clk_en @ 15 {
            bits 1;
            reset 0x1;
            access rw;
        }
        field phy3_refb_lane_clk_en @ 16 {
            bits 1;
            reset 0x1;
            access rw;
        }
        field phy3_ref_repeat_clk_en @ 17 {
            bits 1;
            reset 0x1;
            access rw;
        }
        field phy3_ref_repeat_clk_sel @ 18 {
            bits 2;
            reset 0x1;
            access rw;
        }
        field phy3_refa_clk_sel @ 20 {
            bits 2;
            reset 0x1;
            access rw;
        }
        field phy3_refa_clkdet_en @ 22 {
            bits 1;
            reset 0x0;
            access rw;
        }
        field reserved @ 23 {
            bits 1;
            reset 0x0;
            access rw;
        }
        field phy3_refb_clk_sel @ 24 {
            bits 2;
            reset 0x1;
            access rw;
        }
        field phy3_refb_clkdet_en @ 26 {
            bits 1;
            reset 0x0;
            access rw;
        }
        field reserved @ 27 {
            bits 1;
            reset 0x0;
            access rw;
        }
        field phy3_fw_clk_range @ 28 {
            bits 4;
            reset 0x3;
            access rw;
        }
    }
    register PCIEPHY_CTRL_14 @0x38 {
    bytes 4;
        field phy3_rx_term_offset {
            bits 5;
            reset 0x0;
            access rw;
        }
        field phy3_txdn_term_offset @ 5 {
            bits 9;
            reset 0x0;
            access rw;
        }
        field phy3_txup_term_offset @ 14 {
            bits 9;
            reset 0x0;
            access rw;
        }
        field phy3_sram_bootload_bypass @ 23 {
            bits 1;
            reset 0x1;
            access rw;
        }
        field phy3_sram_bypass @ 24 {
            bits 1;
            reset 0x1;
            access rw;
        }
        field phy3_sram_ecc_en @ 25 {
            bits 1;
            reset 0x0;
            access rw;
        }
        field phy3_sram_ext_ld_done @ 26 {
            bits 1;
            reset 0x0;
            access rw;
        }
        field reserved @ 27 {
            bits 1;
            reset 0x0;
            access rw;
        }
        field phy3_refa_clk_div2_en @ 28 {
            bits 1;
            reset 0x0;
            access rw;
        }
        field phy3_refa_raw_clk_div2_en @ 29 {
            bits 1;
            reset 0x0;
            access rw;
        }
        field phy3_refb_clk_div2_en @ 30 {
            bits 1;
            reset 0x0;
            access rw;
        }
        field phy3_refb_raw_clk_div2_en @ 31 {
            bits 1;
            reset 0x0;
            access rw;
        }
    }
    register PCIEPHY_CTRL_15 @0x3C {
    bytes 4;
        field phy3_refa_range {
            bits 4;
            reset 0x3;
            access rw;
        }
        field phy3_refb_range @ 4 {
            bits 4;
            reset 0x3;
            access rw;
        }
        field phy3_sup_misc @ 7 {
            bits 24;
            reset 0x0;
            access rw;
        }
    }
    register PCIEPHY_CTRL_16 @0x40 {
    bytes 4;
        field phy_lane0_cntx_en {
            bits 1;
            reset 0x0;
            access rw;
        }
        field phy_lane0_ref_sel @ 1 {
            bits 1;
            reset 0x0;
            access rw;
        }
        field phy_lane0_refa_clk_en @ 2 {
            bits 1;
            reset 0x1;
            access rw;
        }
        field phy_lane0_refb_clk_en @ 3 {
            bits 1;
            reset 0x1;
            access rw;
        }
        field phy_lane0_rx2tx_par_lb_en @ 4 {
            bits 1;
            reset 0x0;
            access rw;
        }
        field phy_lane1_cntx_en @ 5 {
            bits 1;
            reset 0x0;
            access rw;
        }
        field phy_lane1_ref_sel @ 6 {
            bits 1;
            reset 0x0;
            access rw;
        }
        field phy_lane1_refa_clk_en @ 7 {
            bits 1;
            reset 0x1;
            access rw;
        }
        field phy_lane1_refb_clk_en @ 8 {
            bits 1;
            reset 0x1;
            access rw;
        }
        field phy_lane1_rx2tx_par_lb_en @ 9 {
            bits 1;
            reset 0x0;
            access rw;
        }
        field phy_lane2_cntx_en @ 10 {
            bits 1;
            reset 0x0;
            access rw;
        }
        field phy_lane2_ref_sel @ 11 {
            bits 1;
            reset 0x0;
            access rw;
        }
        field phy_lane2_refa_clk_en @ 12 {
            bits 1;
            reset 0x1;
            access rw;
        }
        field phy_lane2_refb_clk_en @ 13 {
            bits 1;
            reset 0x1;
            access rw;
        }
        field phy_lane2_rx2tx_par_lb_en @ 14 {
            bits 1;
            reset 0x0;
            access rw;
        }
        field phy_lane3_cntx_en @ 15 {
            bits 1;
            reset 0x0;
            access rw;
        }
        field phy_lane3_ref_sel @ 16 {
            bits 1;
            reset 0x0;
            access rw;
        }
        field phy_lane3_refa_clk_en @ 17 {
            bits 1;
            reset 0x1;
            access rw;
        }
        field phy_lane3_refb_clk_en @ 18 {
            bits 1;
            reset 0x1;
            access rw;
        }
        field phy_lane3_rx2tx_par_lb_en @ 19 {
            bits 1;
            reset 0x0;
            access rw;
        }
        field phy_lane4_cntx_en @ 20 {
            bits 1;
            reset 0x0;
            access rw;
        }
        field phy_lane4_ref_sel @ 21 {
            bits 1;
            reset 0x0;
            access rw;
        }
        field phy_lane4_refa_clk_en @ 22 {
            bits 1;
            reset 0x1;
            access rw;
        }
        field phy_lane4_refb_clk_en @ 23 {
            bits 1;
            reset 0x1;
            access rw;
        }
        field phy_lane4_rx2tx_par_lb_en @ 24 {
            bits 1;
            reset 0x0;
            access rw;
        }
        field phy_lane5_cntx_en @ 25 {
            bits 1;
            reset 0x0;
            access rw;
        }
        field phy_lane5_ref_sel @ 26 {
            bits 1;
            reset 0x0;
            access rw;
        }
        field phy_lane5_refa_clk_en @ 27 {
            bits 1;
            reset 0x1;
            access rw;
        }
        field phy_lane5_refb_clk_en @ 28 {
            bits 1;
            reset 0x1;
            access rw;
        }
        field phy_lane5_rx2tx_par_lb_en @ 29 {
            bits 1;
            reset 0x0;
            access rw;
        }
    }
    register PCIEPHY_CTRL_17 @0x44 {
    bytes 4;
        field phy_lane6_cntx_en {
            bits 1;
            reset 0x0;
            access rw;
        }
        field phy_lane6_ref_sel @ 1 {
            bits 1;
            reset 0x0;
            access rw;
        }
        field phy_lane6_refa_clk_en @ 2 {
            bits 1;
            reset 0x1;
            access rw;
        }
        field phy_lane6_refb_clk_en @ 3 {
            bits 1;
            reset 0x1;
            access rw;
        }
        field phy_lane6_rx2tx_par_lb_en @ 4 {
            bits 1;
            reset 0x0;
            access rw;
        }
        field phy_lane7_cntx_en @ 5 {
            bits 1;
            reset 0x0;
            access rw;
        }
        field phy_lane7_ref_sel @ 6 {
            bits 1;
            reset 0x0;
            access rw;
        }
        field phy_lane7_refa_clk_en @ 7 {
            bits 1;
            reset 0x1;
            access rw;
        }
        field phy_lane7_refb_clk_en @ 8 {
            bits 1;
            reset 0x1;
            access rw;
        }
        field phy_lane7_rx2tx_par_lb_en @ 9 {
            bits 1;
            reset 0x0;
            access rw;
        }
        field phy_lane8_cntx_en @ 10 {
            bits 1;
            reset 0x0;
            access rw;
        }
        field phy_lane8_ref_sel @ 11 {
            bits 1;
            reset 0x0;
            access rw;
        }
        field phy_lane8_refa_clk_en @ 12 {
            bits 1;
            reset 0x1;
            access rw;
        }
        field phy_lane8_refb_clk_en @ 13 {
            bits 1;
            reset 0x1;
            access rw;
        }
        field phy_lane8_rx2tx_par_lb_en @ 14 {
            bits 1;
            reset 0x0;
            access rw;
        }
        field phy_lane9_cntx_en @ 15 {
            bits 1;
            reset 0x0;
            access rw;
        }
        field phy_lane9_ref_sel @ 16 {
            bits 1;
            reset 0x0;
            access rw;
        }
        field phy_lane9_refa_clk_en @ 17 {
            bits 1;
            reset 0x1;
            access rw;
        }
        field phy_lane9_refb_clk_en @ 18 {
            bits 1;
            reset 0x1;
            access rw;
        }
        field phy_lane9_rx2tx_par_lb_en @ 19 {
            bits 1;
            reset 0x0;
            access rw;
        }
        field phy_lane10_cntx_en @ 20 {
            bits 1;
            reset 0x0;
            access rw;
        }
        field phy_lane10_ref_sel @ 21 {
            bits 1;
            reset 0x0;
            access rw;
        }
        field phy_lane10_refa_clk_en @ 22 {
            bits 1;
            reset 0x1;
            access rw;
        }
        field phy_lane10_refb_clk_en @ 23 {
            bits 1;
            reset 0x1;
            access rw;
        }
        field phy_lane10_rx2tx_par_lb_en @ 24 {
            bits 1;
            reset 0x0;
            access rw;
        }
        field phy_lane11_cntx_en @ 25 {
            bits 1;
            reset 0x0;
            access rw;
        }
        field phy_lane11_ref_sel @ 26 {
            bits 1;
            reset 0x0;
            access rw;
        }
        field phy_lane11_refa_clk_en @ 27 {
            bits 1;
            reset 0x1;
            access rw;
        }
        field phy_lane11_refb_clk_en @ 28 {
            bits 1;
            reset 0x1;
            access rw;
        }
        field phy_lane11_rx2tx_par_lb_en @ 29 {
            bits 1;
            reset 0x0;
            access rw;
        }
    }
    register PCIEPHY_CTRL_18 @0x48 {
    bytes 4;
        field phy_lane12_cntx_en {
            bits 1;
            reset 0x0;
            access rw;
        }
        field phy_lane12_ref_sel @ 1 {
            bits 1;
            reset 0x0;
            access rw;
        }
        field phy_lane12_refa_clk_en @ 2 {
            bits 1;
            reset 0x1;
            access rw;
        }
        field phy_lane12_refb_clk_en @ 3 {
            bits 1;
            reset 0x1;
            access rw;
        }
        field phy_lane12_rx2tx_par_lb_en @ 4 {
            bits 1;
            reset 0x0;
            access rw;
        }
        field phy_lane13_cntx_en @ 5 {
            bits 1;
            reset 0x0;
            access rw;
        }
        field phy_lane13_ref_sel @ 6 {
            bits 1;
            reset 0x0;
            access rw;
        }
        field phy_lane13_refa_clk_en @ 7 {
            bits 1;
            reset 0x1;
            access rw;
        }
        field phy_lane13_refb_clk_en @ 8 {
            bits 1;
            reset 0x1;
            access rw;
        }
        field phy_lane13_rx2tx_par_lb_en @ 9 {
            bits 1;
            reset 0x0;
            access rw;
        }
        field phy_lane14_cntx_en @ 10 {
            bits 1;
            reset 0x0;
            access rw;
        }
        field phy_lane14_ref_sel @ 11 {
            bits 1;
            reset 0x0;
            access rw;
        }
        field phy_lane14_refa_clk_en @ 12 {
            bits 1;
            reset 0x1;
            access rw;
        }
        field phy_lane14_refb_clk_en @ 13 {
            bits 1;
            reset 0x1;
            access rw;
        }
        field phy_lane14_rx2tx_par_lb_en @ 14 {
            bits 1;
            reset 0x0;
            access rw;
        }
        field phy_lane15_cntx_en @ 15 {
            bits 1;
            reset 0x0;
            access rw;
        }
        field phy_lane15_ref_sel @ 16 {
            bits 1;
            reset 0x0;
            access rw;
        }
        field phy_lane15_refa_clk_en @ 17 {
            bits 1;
            reset 0x1;
            access rw;
        }
        field phy_lane15_refb_clk_en @ 18 {
            bits 1;
            reset 0x1;
            access rw;
        }
        field phy_lane15_rx2tx_par_lb_en @ 19 {
            bits 1;
            reset 0x0;
            access rw;
        }
        field phy_rx_protocol_family_id @ 20 {
            bits 4;
            reset 0x1;
            access rw;
        }
        field phy_tx_protocol_family_id @ 24 {
            bits 4;
            reset 0x1;
            access rw;
        }
    }
    register PCIEPHY_CTRL_19 @0x4C {
    bytes 4;
        field reserved {
            bits 6;
            reset 0x1;
            access rw;
        }
        field phy_rx0_cntx_sel_g1 @ 6 {
            bits 8;
            reset 0x0;
            access rw;
        }
    }
    register PCIEPHY_CTRL_20 @0x50 {
    bytes 4;
        field phy_rx0_cntx_sel_g2 {
            bits 8;
            reset 0x0;
            access rw;
        }
        field phy_rx0_cntx_sel_g3 @ 8 {
            bits 8;
            reset 0x0;
            access rw;
        }
        field phy_rx0_cntx_sel_g4 @ 16 {
            bits 8;
            reset 0x0;
            access rw;
        }
        field phy_rx0_cntx_sel_g5 @ 24 {
            bits 8;
            reset 0x0;
            access rw;
        }
    }
    register PCIEPHY_CTRL_21 @0x54 {
    bytes 4;
        field reserved {
            bits 6;
            reset 0x1;
            access rw;
        }
        field phy_rx1_cntx_sel_g1 @ 6 {
            bits 8;
            reset 0x0;
            access rw;
        }
    }
    register PCIEPHY_CTRL_22 @0x58 {
    bytes 4;
        field phy_rx1_cntx_sel_g2 {
            bits 8;
            reset 0x0;
            access rw;
        }
        field phy_rx1_cntx_sel_g3 @ 8 {
            bits 8;
            reset 0x0;
            access rw;
        }
        field phy_rx1_cntx_sel_g4 @ 16 {
            bits 8;
            reset 0x0;
            access rw;
        }
        field phy_rx1_cntx_sel_g5 @ 24 {
            bits 8;
            reset 0x0;
            access rw;
        }
    }
    register PCIEPHY_CTRL_23 @0x5C {
    bytes 4;
        field reserved {
            bits 6;
            reset 0x1;
            access rw;
        }
        field phy_rx2_cntx_sel_g1 @ 6 {
            bits 8;
            reset 0x0;
            access rw;
        }
    }
    register PCIEPHY_CTRL_24 @0x60 {
    bytes 4;
        field phy_rx2_cntx_sel_g2 {
            bits 8;
            reset 0x0;
            access rw;
        }
        field phy_rx2_cntx_sel_g3 @ 8 {
            bits 8;
            reset 0x0;
            access rw;
        }
        field phy_rx2_cntx_sel_g4 @ 16 {
            bits 8;
            reset 0x0;
            access rw;
        }
        field phy_rx2_cntx_sel_g5 @ 24 {
            bits 8;
            reset 0x0;
            access rw;
        }
    }
    register PCIEPHY_CTRL_25 @0x64 {
    bytes 4;
        field reserved {
            bits 6;
            reset 0x1;
            access rw;
        }
        field phy_rx3_cntx_sel_g1 @ 6 {
            bits 8;
            reset 0x0;
            access rw;
        }
    }
    register PCIEPHY_CTRL_26 @0x68 {
    bytes 4;
        field phy_rx3_cntx_sel_g2 {
            bits 8;
            reset 0x0;
            access rw;
        }
        field phy_rx3_cntx_sel_g3 @ 8 {
            bits 8;
            reset 0x0;
            access rw;
        }
        field phy_rx3_cntx_sel_g4 @ 16 {
            bits 8;
            reset 0x0;
            access rw;
        }
        field phy_rx3_cntx_sel_g5 @ 24 {
            bits 8;
            reset 0x0;
            access rw;
        }
    }
    register PCIEPHY_CTRL_27 @0x6C {
    bytes 4;
        field reserved {
            bits 6;
            reset 0x1;
            access rw;
        }
        field phy_rx4_cntx_sel_g1 @ 6 {
            bits 8;
            reset 0x0;
            access rw;
        }
    }
    register PCIEPHY_CTRL_28 @0x70 {
    bytes 4;
        field phy_rx4_cntx_sel_g2 {
            bits 8;
            reset 0x0;
            access rw;
        }
        field phy_rx4_cntx_sel_g3 @ 8 {
            bits 8;
            reset 0x0;
            access rw;
        }
        field phy_rx4_cntx_sel_g4 @ 16 {
            bits 8;
            reset 0x0;
            access rw;
        }
        field phy_rx4_cntx_sel_g5 @ 24 {
            bits 8;
            reset 0x0;
            access rw;
        }
    }
    register PCIEPHY_CTRL_29 @0x74 {
    bytes 4;
        field reserved {
            bits 6;
            reset 0x1;
            access rw;
        }
        field phy_rx5_cntx_sel_g1 @ 6 {
            bits 8;
            reset 0x0;
            access rw;
        }
    }
    register PCIEPHY_CTRL_30 @0x78 {
    bytes 4;
        field phy_rx5_cntx_sel_g2 {
            bits 8;
            reset 0x0;
            access rw;
        }
        field phy_rx5_cntx_sel_g3 @ 8 {
            bits 8;
            reset 0x0;
            access rw;
        }
        field phy_rx5_cntx_sel_g4 @ 16 {
            bits 8;
            reset 0x0;
            access rw;
        }
        field phy_rx5_cntx_sel_g5 @ 24 {
            bits 8;
            reset 0x0;
            access rw;
        }
    }
    register PCIEPHY_CTRL_31 @0x7C {
    bytes 4;
        field reserved {
            bits 6;
            reset 0x1;
            access rw;
        }
        field phy_rx6_cntx_sel_g1 @ 6 {
            bits 8;
            reset 0x0;
            access rw;
        }
    }
    register PCIEPHY_CTRL_32 @0x80 {
    bytes 4;
        field phy_rx6_cntx_sel_g2 {
            bits 8;
            reset 0x0;
            access rw;
        }
        field phy_rx6_cntx_sel_g3 @ 8 {
            bits 8;
            reset 0x0;
            access rw;
        }
        field phy_rx6_cntx_sel_g4 @ 16 {
            bits 8;
            reset 0x0;
            access rw;
        }
        field phy_rx6_cntx_sel_g5 @ 24 {
            bits 8;
            reset 0x0;
            access rw;
        }
    }
    register PCIEPHY_CTRL_33 @0x84 {
    bytes 4;
        field reserved {
            bits 6;
            reset 0x1;
            access rw;
        }
        field phy_rx7_cntx_sel_g1 @ 6 {
            bits 8;
            reset 0x0;
            access rw;
        }
    }
    register PCIEPHY_CTRL_34 @0x88 {
    bytes 4;
        field phy_rx7_cntx_sel_g2 {
            bits 8;
            reset 0x0;
            access rw;
        }
        field phy_rx7_cntx_sel_g3 @ 8 {
            bits 8;
            reset 0x0;
            access rw;
        }
        field phy_rx7_cntx_sel_g4 @ 16 {
            bits 8;
            reset 0x0;
            access rw;
        }
        field phy_rx7_cntx_sel_g5 @ 24 {
            bits 8;
            reset 0x0;
            access rw;
        }
    }
    register PCIEPHY_CTRL_35 @0x8C {
    bytes 4;
        field reserved {
            bits 6;
            reset 0x1;
            access rw;
        }
        field phy_rx8_cntx_sel_g1 @ 6 {
            bits 8;
            reset 0x0;
            access rw;
        }
    }
    register PCIEPHY_CTRL_36 @0x90 {
    bytes 4;
        field phy_rx8_cntx_sel_g2 {
            bits 8;
            reset 0x0;
            access rw;
        }
        field phy_rx8_cntx_sel_g3 @ 8 {
            bits 8;
            reset 0x0;
            access rw;
        }
        field phy_rx8_cntx_sel_g4 @ 16 {
            bits 8;
            reset 0x0;
            access rw;
        }
        field phy_rx8_cntx_sel_g5 @ 24 {
            bits 8;
            reset 0x0;
            access rw;
        }
    }
    register PCIEPHY_CTRL_37 @0x94 {
    bytes 4;
        field reserved {
            bits 6;
            reset 0x1;
            access rw;
        }
        field phy_rx9_cntx_sel_g1 @ 6 {
            bits 8;
            reset 0x0;
            access rw;
        }
    }
    register PCIEPHY_CTRL_38 @0x98 {
    bytes 4;
        field phy_rx9_cntx_sel_g2 {
            bits 8;
            reset 0x0;
            access rw;
        }
        field phy_rx9_cntx_sel_g3 @ 8 {
            bits 8;
            reset 0x0;
            access rw;
        }
        field phy_rx9_cntx_sel_g4 @ 16 {
            bits 8;
            reset 0x0;
            access rw;
        }
        field phy_rx9_cntx_sel_g5 @ 24 {
            bits 8;
            reset 0x0;
            access rw;
        }
    }
    register PCIEPHY_CTRL_39 @0x9C {
    bytes 4;
        field reserved {
            bits 6;
            reset 0x1;
            access rw;
        }
        field phy_rx10_cntx_sel_g1 @ 6 {
            bits 8;
            reset 0x0;
            access rw;
        }
    }
    register PCIEPHY_CTRL_40 @0xA0 {
    bytes 4;
        field phy_rx10_cntx_sel_g2 {
            bits 8;
            reset 0x0;
            access rw;
        }
        field phy_rx10_cntx_sel_g3 @ 8 {
            bits 8;
            reset 0x0;
            access rw;
        }
        field phy_rx10_cntx_sel_g4 @ 16 {
            bits 8;
            reset 0x0;
            access rw;
        }
        field phy_rx10_cntx_sel_g5 @ 24 {
            bits 8;
            reset 0x0;
            access rw;
        }
    }
    register PCIEPHY_CTRL_41 @0xA4 {
    bytes 4;
        field reserved {
            bits 6;
            reset 0x1;
            access rw;
        }
        field phy_rx11_cntx_sel_g1 @ 6 {
            bits 8;
            reset 0x0;
            access rw;
        }
    }
    register PCIEPHY_CTRL_42 @0xA8 {
    bytes 4;
        field phy_rx11_cntx_sel_g2 {
            bits 8;
            reset 0x0;
            access rw;
        }
        field phy_rx11_cntx_sel_g3 @ 8 {
            bits 8;
            reset 0x0;
            access rw;
        }
        field phy_rx11_cntx_sel_g4 @ 16 {
            bits 8;
            reset 0x0;
            access rw;
        }
        field phy_rx11_cntx_sel_g5 @ 24 {
            bits 8;
            reset 0x0;
            access rw;
        }
    }
    register PCIEPHY_CTRL_43 @0xAC {
    bytes 4;
        field reserved {
            bits 6;
            reset 0x1;
            access rw;
        }
        field phy_rx12_cntx_sel_g1 @ 6 {
            bits 8;
            reset 0x0;
            access rw;
        }
    }
    register PCIEPHY_CTRL_44 @0xB0 {
    bytes 4;
        field phy_rx12_cntx_sel_g2 {
            bits 8;
            reset 0x0;
            access rw;
        }
        field phy_rx12_cntx_sel_g3 @ 8 {
            bits 8;
            reset 0x0;
            access rw;
        }
        field phy_rx12_cntx_sel_g4 @ 16 {
            bits 8;
            reset 0x0;
            access rw;
        }
        field phy_rx12_cntx_sel_g5 @ 24 {
            bits 8;
            reset 0x0;
            access rw;
        }
    }
    register PCIEPHY_CTRL_45 @0xB4 {
    bytes 4;
        field reserved {
            bits 6;
            reset 0x1;
            access rw;
        }
        field phy_rx13_cntx_sel_g1 @ 6 {
            bits 8;
            reset 0x0;
            access rw;
        }
    }
    register PCIEPHY_CTRL_46 @0xB8 {
    bytes 4;
        field phy_rx13_cntx_sel_g2 {
            bits 8;
            reset 0x0;
            access rw;
        }
        field phy_rx13_cntx_sel_g3 @ 8 {
            bits 8;
            reset 0x0;
            access rw;
        }
        field phy_rx13_cntx_sel_g4 @ 16 {
            bits 8;
            reset 0x0;
            access rw;
        }
        field phy_rx13_cntx_sel_g5 @ 24 {
            bits 8;
            reset 0x0;
            access rw;
        }
    }
    register PCIEPHY_CTRL_47 @0xBC {
    bytes 4;
        field reserved {
            bits 6;
            reset 0x1;
            access rw;
        }
        field phy_rx14_cntx_sel_g1 @ 6 {
            bits 8;
            reset 0x0;
            access rw;
        }
    }
    register PCIEPHY_CTRL_48 @0xC0 {
    bytes 4;
        field phy_rx14_cntx_sel_g2 {
            bits 8;
            reset 0x0;
            access rw;
        }
        field phy_rx14_cntx_sel_g3 @ 8 {
            bits 8;
            reset 0x0;
            access rw;
        }
        field phy_rx14_cntx_sel_g4 @ 16 {
            bits 8;
            reset 0x0;
            access rw;
        }
        field phy_rx14_cntx_sel_g5 @ 24 {
            bits 8;
            reset 0x0;
            access rw;
        }
    }
    register PCIEPHY_CTRL_49 @0xC4 {
    bytes 4;
        field reserved {
            bits 6;
            reset 0x1;
            access rw;
        }
        field phy_rx15_cntx_sel_g1 @ 6 {
            bits 8;
            reset 0x0;
            access rw;
        }
    }
    register PCIEPHY_CTRL_50 @0xC8 {
    bytes 4;
        field phy_rx15_cntx_sel_g2 {
            bits 8;
            reset 0x0;
            access rw;
        }
        field phy_rx15_cntx_sel_g3 @ 8 {
            bits 8;
            reset 0x0;
            access rw;
        }
        field phy_rx15_cntx_sel_g4 @ 16 {
            bits 8;
            reset 0x0;
            access rw;
        }
        field phy_rx15_cntx_sel_g5 @ 24 {
            bits 8;
            reset 0x0;
            access rw;
        }
    }
    register PCIEPHY_CTRL_51 @0xCC {
    bytes 4;
        field phy_tx_cmn0_cntx_sel_g1 {
            bits 8;
            reset 0x0;
            access rw;
        }
        field phy_tx_cmn0_cntx_sel_g2 @ 8 {
            bits 8;
            reset 0x0;
            access rw;
        }
        field phy_tx_cmn0_cntx_sel_g3 @ 16 {
            bits 8;
            reset 0x0;
            access rw;
        }
        field phy_tx_cmn0_cntx_sel_g4 @ 24 {
            bits 8;
            reset 0x0;
            access rw;
        }
    }
    register PCIEPHY_CTRL_52 @0xD0 {
    bytes 4;
        field phy_tx0_cntx_sel_g1 {
            bits 8;
            reset 0x0;
            access rw;
        }
        field phy_tx0_cntx_sel_g2 @ 8 {
            bits 8;
            reset 0x0;
            access rw;
        }
        field phy_tx0_cntx_sel_g3 @ 16 {
            bits 8;
            reset 0x0;
            access rw;
        }
        field phy_tx0_cntx_sel_g4 @ 24 {
            bits 8;
            reset 0x0;
            access rw;
        }
    }
    register PCIEPHY_CTRL_53 @0xD4 {
    bytes 4;
        field phy_tx_cmn1_cntx_sel_g1 {
            bits 8;
            reset 0x0;
            access rw;
        }
        field phy_tx_cmn1_cntx_sel_g2 @ 8 {
            bits 8;
            reset 0x0;
            access rw;
        }
        field phy_tx_cmn1_cntx_sel_g3 @ 16 {
            bits 8;
            reset 0x0;
            access rw;
        }
        field phy_tx_cmn1_cntx_sel_g4 @ 24 {
            bits 8;
            reset 0x0;
            access rw;
        }
    }
    register PCIEPHY_CTRL_54 @0xD8 {
    bytes 4;
        field phy_tx1_cntx_sel_g1 {
            bits 8;
            reset 0x0;
            access rw;
        }
        field phy_tx1_cntx_sel_g2 @ 8 {
            bits 8;
            reset 0x0;
            access rw;
        }
        field phy_tx1_cntx_sel_g3 @ 16 {
            bits 8;
            reset 0x0;
            access rw;
        }
        field phy_tx1_cntx_sel_g4 @ 24 {
            bits 8;
            reset 0x0;
            access rw;
        }
    }
    register PCIEPHY_CTRL_55 @0xDC {
    bytes 4;
        field phy_tx_cmn2_cntx_sel_g1 {
            bits 8;
            reset 0x0;
            access rw;
        }
        field phy_tx_cmn2_cntx_sel_g2 @ 8 {
            bits 8;
            reset 0x0;
            access rw;
        }
        field phy_tx_cmn2_cntx_sel_g3 @ 16 {
            bits 8;
            reset 0x0;
            access rw;
        }
        field phy_tx_cmn2_cntx_sel_g4 @ 24 {
            bits 8;
            reset 0x0;
            access rw;
        }
    }
    register PCIEPHY_CTRL_56 @0xE0 {
    bytes 4;
        field phy_tx2_cntx_sel_g1 {
            bits 8;
            reset 0x0;
            access rw;
        }
        field phy_tx2_cntx_sel_g2 @ 8 {
            bits 8;
            reset 0x0;
            access rw;
        }
        field phy_tx2_cntx_sel_g3 @ 16 {
            bits 8;
            reset 0x0;
            access rw;
        }
        field phy_tx2_cntx_sel_g4 @ 24 {
            bits 8;
            reset 0x0;
            access rw;
        }
    }
    register PCIEPHY_CTRL_57 @0xE4 {
    bytes 4;
        field phy_tx_cmn3_cntx_sel_g1 {
            bits 8;
            reset 0x0;
            access rw;
        }
        field phy_tx_cmn3_cntx_sel_g2 @ 8 {
            bits 8;
            reset 0x0;
            access rw;
        }
        field phy_tx_cmn3_cntx_sel_g3 @ 16 {
            bits 8;
            reset 0x0;
            access rw;
        }
        field phy_tx_cmn3_cntx_sel_g4 @ 24 {
            bits 8;
            reset 0x0;
            access rw;
        }
    }
    register PCIEPHY_CTRL_58 @0xE8 {
    bytes 4;
        field phy_tx3_cntx_sel_g1 {
            bits 8;
            reset 0x0;
            access rw;
        }
        field phy_tx3_cntx_sel_g2 @ 8 {
            bits 8;
            reset 0x0;
            access rw;
        }
        field phy_tx3_cntx_sel_g3 @ 16 {
            bits 8;
            reset 0x0;
            access rw;
        }
        field phy_tx3_cntx_sel_g4 @ 24 {
            bits 8;
            reset 0x0;
            access rw;
        }
    }
    register PCIEPHY_CTRL_59 @0xEC {
    bytes 4;
        field phy_tx_cmn4_cntx_sel_g1 {
            bits 8;
            reset 0x0;
            access rw;
        }
        field phy_tx_cmn4_cntx_sel_g2 @ 8 {
            bits 8;
            reset 0x0;
            access rw;
        }
        field phy_tx_cmn4_cntx_sel_g3 @ 16 {
            bits 8;
            reset 0x0;
            access rw;
        }
        field phy_tx_cmn4_cntx_sel_g4 @ 24 {
            bits 8;
            reset 0x0;
            access rw;
        }
    }
    register PCIEPHY_CTRL_60 @0xF0 {
    bytes 4;
        field phy_tx4_cntx_sel_g1 {
            bits 8;
            reset 0x0;
            access rw;
        }
        field phy_tx4_cntx_sel_g2 @ 8 {
            bits 8;
            reset 0x0;
            access rw;
        }
        field phy_tx4_cntx_sel_g3 @ 16 {
            bits 8;
            reset 0x0;
            access rw;
        }
        field phy_tx4_cntx_sel_g4 @ 24 {
            bits 8;
            reset 0x0;
            access rw;
        }
    }
    register PCIEPHY_CTRL_61 @0xF4 {
    bytes 4;
        field phy_tx_cmn5_cntx_sel_g1 {
            bits 8;
            reset 0x0;
            access rw;
        }
        field phy_tx_cmn5_cntx_sel_g2 @ 8 {
            bits 8;
            reset 0x0;
            access rw;
        }
        field phy_tx_cmn5_cntx_sel_g3 @ 16 {
            bits 8;
            reset 0x0;
            access rw;
        }
        field phy_tx_cmn5_cntx_sel_g4 @ 24 {
            bits 8;
            reset 0x0;
            access rw;
        }
    }
    register PCIEPHY_CTRL_62 @0xF8 {
    bytes 4;
        field phy_tx5_cntx_sel_g1 {
            bits 8;
            reset 0x0;
            access rw;
        }
        field phy_tx5_cntx_sel_g2 @ 8 {
            bits 8;
            reset 0x0;
            access rw;
        }
        field phy_tx5_cntx_sel_g3 @ 16 {
            bits 8;
            reset 0x0;
            access rw;
        }
        field phy_tx5_cntx_sel_g4 @ 24 {
            bits 8;
            reset 0x0;
            access rw;
        }
    }
    register PCIEPHY_CTRL_63 @0xFC {
    bytes 4;
        field phy_tx_cmn6_cntx_sel_g1 {
            bits 8;
            reset 0x0;
            access rw;
        }
        field phy_tx_cmn6_cntx_sel_g2 @ 8 {
            bits 8;
            reset 0x0;
            access rw;
        }
        field phy_tx_cmn6_cntx_sel_g3 @ 16 {
            bits 8;
            reset 0x0;
            access rw;
        }
        field phy_tx_cmn6_cntx_sel_g4 @ 24 {
            bits 8;
            reset 0x0;
            access rw;
        }
    }
    register PCIEPHY_CTRL_64 @0x100 {
    bytes 4;
        field phy_tx6_cntx_sel_g1 {
            bits 8;
            reset 0x0;
            access rw;
        }
        field phy_tx6_cntx_sel_g2 @ 8 {
            bits 8;
            reset 0x0;
            access rw;
        }
        field phy_tx6_cntx_sel_g3 @ 16 {
            bits 8;
            reset 0x0;
            access rw;
        }
        field phy_tx6_cntx_sel_g4 @ 24 {
            bits 8;
            reset 0x0;
            access rw;
        }
    }
    register PCIEPHY_CTRL_65 @0x104 {
    bytes 4;
        field phy_tx_cmn7_cntx_sel_g1 {
            bits 8;
            reset 0x0;
            access rw;
        }
        field phy_tx_cmn7_cntx_sel_g2 @ 8 {
            bits 8;
            reset 0x0;
            access rw;
        }
        field phy_tx_cmn7_cntx_sel_g3 @ 16 {
            bits 8;
            reset 0x0;
            access rw;
        }
        field phy_tx_cmn7_cntx_sel_g4 @ 24 {
            bits 8;
            reset 0x0;
            access rw;
        }
    }
    register PCIEPHY_CTRL_66 @0x108 {
    bytes 4;
        field phy_tx7_cntx_sel_g1 {
            bits 8;
            reset 0x0;
            access rw;
        }
        field phy_tx7_cntx_sel_g2 @ 8 {
            bits 8;
            reset 0x0;
            access rw;
        }
        field phy_tx7_cntx_sel_g3 @ 16 {
            bits 8;
            reset 0x0;
            access rw;
        }
        field phy_tx7_cntx_sel_g4 @ 24 {
            bits 8;
            reset 0x0;
            access rw;
        }
    }
    register PCIEPHY_CTRL_67 @0x10C {
    bytes 4;
        field phy_tx_cmn8_cntx_sel_g1 {
            bits 8;
            reset 0x0;
            access rw;
        }
        field phy_tx_cmn8_cntx_sel_g2 @ 8 {
            bits 8;
            reset 0x0;
            access rw;
        }
        field phy_tx_cmn8_cntx_sel_g3 @ 16 {
            bits 8;
            reset 0x0;
            access rw;
        }
        field phy_tx_cmn8_cntx_sel_g4 @ 24 {
            bits 8;
            reset 0x0;
            access rw;
        }
    }
    register PCIEPHY_CTRL_68 @0x110 {
    bytes 4;
        field phy_tx8_cntx_sel_g1 {
            bits 8;
            reset 0x0;
            access rw;
        }
        field phy_tx8_cntx_sel_g2 @ 8 {
            bits 8;
            reset 0x0;
            access rw;
        }
        field phy_tx8_cntx_sel_g3 @ 16 {
            bits 8;
            reset 0x0;
            access rw;
        }
        field phy_tx8_cntx_sel_g4 @ 24 {
            bits 8;
            reset 0x0;
            access rw;
        }
    }
    register PCIEPHY_CTRL_69 @0x114 {
    bytes 4;
        field phy_tx_cmn9_cntx_sel_g1 {
            bits 8;
            reset 0x0;
            access rw;
        }
        field phy_tx_cmn9_cntx_sel_g2 @ 8 {
            bits 8;
            reset 0x0;
            access rw;
        }
        field phy_tx_cmn9_cntx_sel_g3 @ 16 {
            bits 8;
            reset 0x0;
            access rw;
        }
        field phy_tx_cmn9_cntx_sel_g4 @ 24 {
            bits 8;
            reset 0x0;
            access rw;
        }
    }
    register PCIEPHY_CTRL_70 @0x118 {
    bytes 4;
        field phy_tx9_cntx_sel_g1 {
            bits 8;
            reset 0x0;
            access rw;
        }
        field phy_tx9_cntx_sel_g2 @ 8 {
            bits 8;
            reset 0x0;
            access rw;
        }
        field phy_tx9_cntx_sel_g3 @ 16 {
            bits 8;
            reset 0x0;
            access rw;
        }
        field phy_tx9_cntx_sel_g4 @ 24 {
            bits 8;
            reset 0x0;
            access rw;
        }
    }
    register PCIEPHY_CTRL_71 @0x11C {
    bytes 4;
        field phy_tx_cmn10_cntx_sel_g1 {
            bits 8;
            reset 0x0;
            access rw;
        }
        field phy_tx_cmn10_cntx_sel_g2 @ 8 {
            bits 8;
            reset 0x0;
            access rw;
        }
        field phy_tx_cmn10_cntx_sel_g3 @ 16 {
            bits 8;
            reset 0x0;
            access rw;
        }
        field phy_tx_cmn10_cntx_sel_g4 @ 24 {
            bits 8;
            reset 0x0;
            access rw;
        }
    }
    register PCIEPHY_CTRL_72 @0x120 {
    bytes 4;
        field phy_tx10_cntx_sel_g1 {
            bits 8;
            reset 0x0;
            access rw;
        }
        field phy_tx10_cntx_sel_g2 @ 8 {
            bits 8;
            reset 0x0;
            access rw;
        }
        field phy_tx10_cntx_sel_g3 @ 16 {
            bits 8;
            reset 0x0;
            access rw;
        }
        field phy_tx10_cntx_sel_g4 @ 24 {
            bits 8;
            reset 0x0;
            access rw;
        }
    }
    register PCIEPHY_CTRL_73 @0x124 {
    bytes 4;
        field phy_tx_cmn11_cntx_sel_g1 {
            bits 8;
            reset 0x0;
            access rw;
        }
        field phy_tx_cmn11_cntx_sel_g2 @ 8 {
            bits 8;
            reset 0x0;
            access rw;
        }
        field phy_tx_cmn11_cntx_sel_g3 @ 16 {
            bits 8;
            reset 0x0;
            access rw;
        }
        field phy_tx_cmn11_cntx_sel_g4 @ 24 {
            bits 8;
            reset 0x0;
            access rw;
        }
    }
    register PCIEPHY_CTRL_74 @0x128 {
    bytes 4;
        field phy_tx11_cntx_sel_g1 {
            bits 8;
            reset 0x0;
            access rw;
        }
        field phy_tx11_cntx_sel_g2 @ 8 {
            bits 8;
            reset 0x0;
            access rw;
        }
        field phy_tx11_cntx_sel_g3 @ 16 {
            bits 8;
            reset 0x0;
            access rw;
        }
        field phy_tx11_cntx_sel_g4 @ 24 {
            bits 8;
            reset 0x0;
            access rw;
        }
    }
    register PCIEPHY_CTRL_75 @0x12C {
    bytes 4;
        field phy_tx_cmn12_cntx_sel_g1 {
            bits 8;
            reset 0x0;
            access rw;
        }
        field phy_tx_cmn12_cntx_sel_g2 @ 8 {
            bits 8;
            reset 0x0;
            access rw;
        }
        field phy_tx_cmn12_cntx_sel_g3 @ 16 {
            bits 8;
            reset 0x0;
            access rw;
        }
        field phy_tx_cmn12_cntx_sel_g4 @ 24 {
            bits 8;
            reset 0x0;
            access rw;
        }
    }
    register PCIEPHY_CTRL_76 @0x130 {
    bytes 4;
        field phy_tx12_cntx_sel_g1 {
            bits 8;
            reset 0x0;
            access rw;
        }
        field phy_tx12_cntx_sel_g2 @ 8 {
            bits 8;
            reset 0x0;
            access rw;
        }
        field phy_tx12_cntx_sel_g3 @ 16 {
            bits 8;
            reset 0x0;
            access rw;
        }
        field phy_tx12_cntx_sel_g4 @ 24 {
            bits 8;
            reset 0x0;
            access rw;
        }
    }
    register PCIEPHY_CTRL_77 @0x134 {
    bytes 4;
        field phy_tx_cmn13_cntx_sel_g1 {
            bits 8;
            reset 0x0;
            access rw;
        }
        field phy_tx_cmn13_cntx_sel_g2 @ 8 {
            bits 8;
            reset 0x0;
            access rw;
        }
        field phy_tx_cmn13_cntx_sel_g3 @ 16 {
            bits 8;
            reset 0x0;
            access rw;
        }
        field phy_tx_cmn13_cntx_sel_g4 @ 24 {
            bits 8;
            reset 0x0;
            access rw;
        }
    }
    register PCIEPHY_CTRL_78 @0x138 {
    bytes 4;
        field phy_tx13_cntx_sel_g1 {
            bits 8;
            reset 0x0;
            access rw;
        }
        field phy_tx13_cntx_sel_g2 @ 8 {
            bits 8;
            reset 0x0;
            access rw;
        }
        field phy_tx13_cntx_sel_g3 @ 16 {
            bits 8;
            reset 0x0;
            access rw;
        }
        field phy_tx13_cntx_sel_g4 @ 24 {
            bits 8;
            reset 0x0;
            access rw;
        }
    }
    register PCIEPHY_CTRL_79 @0x13C {
    bytes 4;
        field phy_tx_cmn14_cntx_sel_g1 {
            bits 8;
            reset 0x0;
            access rw;
        }
        field phy_tx_cmn14_cntx_sel_g2 @ 8 {
            bits 8;
            reset 0x0;
            access rw;
        }
        field phy_tx_cmn14_cntx_sel_g3 @ 16 {
            bits 8;
            reset 0x0;
            access rw;
        }
        field phy_tx_cmn14_cntx_sel_g4 @ 24 {
            bits 8;
            reset 0x0;
            access rw;
        }
    }
    register PCIEPHY_CTRL_80 @0x140 {
    bytes 4;
        field phy_tx14_cntx_sel_g1 {
            bits 8;
            reset 0x0;
            access rw;
        }
        field phy_tx14_cntx_sel_g2 @ 8 {
            bits 8;
            reset 0x0;
            access rw;
        }
        field phy_tx14_cntx_sel_g3 @ 16 {
            bits 8;
            reset 0x0;
            access rw;
        }
        field phy_tx14_cntx_sel_g4 @ 24 {
            bits 8;
            reset 0x0;
            access rw;
        }
    }
    register PCIEPHY_CTRL_81 @0x144 {
    bytes 4;
        field phy_tx_cmn15_cntx_sel_g1 {
            bits 8;
            reset 0x0;
            access rw;
        }
        field phy_tx_cmn15_cntx_sel_g2 @ 8 {
            bits 8;
            reset 0x0;
            access rw;
        }
        field phy_tx_cmn15_cntx_sel_g3 @ 16 {
            bits 8;
            reset 0x0;
            access rw;
        }
        field phy_tx_cmn15_cntx_sel_g4 @ 24 {
            bits 8;
            reset 0x0;
            access rw;
        }
    }
    register PCIEPHY_CTRL_82 @0x148 {
    bytes 4;
        field phy_tx15_cntx_sel_g1 {
            bits 8;
            reset 0x0;
            access rw;
        }
        field phy_tx15_cntx_sel_g2 @ 8 {
            bits 8;
            reset 0x0;
            access rw;
        }
        field phy_tx15_cntx_sel_g3 @ 16 {
            bits 8;
            reset 0x0;
            access rw;
        }
        field phy_tx15_cntx_sel_g4 @ 24 {
            bits 8;
            reset 0x0;
            access rw;
        }
    }
    register PCIEPHY_CTRL_83 @0x14C {
    bytes 4;
        field phy_tx_cmn0_cntx_sel_g5 {
            bits 8;
            reset 0x0;
            access rw;
        }
        field phy_tx_cmn1_cntx_sel_g5 @ 8 {
            bits 8;
            reset 0x0;
            access rw;
        }
        field phy_tx_cmn2_cntx_sel_g5 @ 16 {
            bits 8;
            reset 0x0;
            access rw;
        }
        field phy_tx_cmn3_cntx_sel_g5 @ 24 {
            bits 8;
            reset 0x0;
            access rw;
        }
    }
    register PCIEPHY_CTRL_84 @0x150 {
    bytes 4;
        field phy_tx_cmn4_cntx_sel_g5 {
            bits 8;
            reset 0x0;
            access rw;
        }
        field phy_tx_cmn5_cntx_sel_g5 @ 8 {
            bits 8;
            reset 0x0;
            access rw;
        }
        field phy_tx_cmn6_cntx_sel_g5 @ 16 {
            bits 8;
            reset 0x0;
            access rw;
        }
        field phy_tx_cmn7_cntx_sel_g5 @ 24 {
            bits 8;
            reset 0x0;
            access rw;
        }
    }
    register PCIEPHY_CTRL_85 @0x154 {
    bytes 4;
        field phy_tx_cmn8_cntx_sel_g5 {
            bits 8;
            reset 0x0;
            access rw;
        }
        field phy_tx_cmn9_cntx_sel_g5 @ 8 {
            bits 8;
            reset 0x0;
            access rw;
        }
        field phy_tx_cmn10_cntx_sel_g5 @ 16 {
            bits 8;
            reset 0x0;
            access rw;
        }
        field phy_tx_cmn11_cntx_sel_g5 @ 24 {
            bits 8;
            reset 0x0;
            access rw;
        }
    }
    register PCIEPHY_CTRL_86 @0x158 {
    bytes 4;
        field phy_tx_cmn12_cntx_sel_g5 {
            bits 8;
            reset 0x0;
            access rw;
        }
        field phy_tx_cmn13_cntx_sel_g5 @ 8 {
            bits 8;
            reset 0x0;
            access rw;
        }
        field phy_tx_cmn14_cntx_sel_g5 @ 16 {
            bits 8;
            reset 0x0;
            access rw;
        }
        field phy_tx_cmn15_cntx_sel_g5 @ 24 {
            bits 8;
            reset 0x0;
            access rw;
        }
    }
    register PCIEPHY_CTRL_87 @0x15C {
    bytes 4;
        field phy_tx0_cntx_sel_g5 {
            bits 8;
            reset 0x0;
            access rw;
        }
        field phy_tx1_cntx_sel_g5 @ 8 {
            bits 8;
            reset 0x0;
            access rw;
        }
        field phy_tx2_cntx_sel_g5 @ 16 {
            bits 8;
            reset 0x0;
            access rw;
        }
        field phy_tx3_cntx_sel_g5 @ 24 {
            bits 8;
            reset 0x0;
            access rw;
        }
    }
    register PCIEPHY_CTRL_88 @0x160 {
    bytes 4;
        field phy_tx4_cntx_sel_g5 {
            bits 8;
            reset 0x0;
            access rw;
        }
        field phy_tx5_cntx_sel_g5 @ 8 {
            bits 8;
            reset 0x0;
            access rw;
        }
        field phy_tx6_cntx_sel_g5 @ 16 {
            bits 8;
            reset 0x0;
            access rw;
        }
        field phy_tx7_cntx_sel_g5 @ 24 {
            bits 8;
            reset 0x0;
            access rw;
        }
    }
    register PCIEPHY_CTRL_89 @0x164 {
    bytes 4;
        field phy_tx8_cntx_sel_g5 {
            bits 8;
            reset 0x0;
            access rw;
        }
        field phy_tx9_cntx_sel_g5 @ 8 {
            bits 8;
            reset 0x0;
            access rw;
        }
        field phy_tx10_cntx_sel_g5 @ 16 {
            bits 8;
            reset 0x0;
            access rw;
        }
        field phy_tx11_cntx_sel_g5 @ 24 {
            bits 8;
            reset 0x0;
            access rw;
        }
    }
    register PCIEPHY_CTRL_90 @0x168 {
    bytes 4;
        field phy_tx12_cntx_sel_g5 {
            bits 8;
            reset 0x0;
            access rw;
        }
        field phy_tx13_cntx_sel_g5 @ 8 {
            bits 8;
            reset 0x0;
            access rw;
        }
        field phy_tx14_cntx_sel_g5 @ 16 {
            bits 8;
            reset 0x0;
            access rw;
        }
        field phy_tx15_cntx_sel_g5 @ 24 {
            bits 8;
            reset 0x0;
            access rw;
        }
    }
    register PCIEPHY_CTRL_91 @0x16C {
    bytes 4;
        field upcs_pipe_config {
            bits 16;
            reset 0x1;
            access rw;
        }
    }
    register PCIEPHY_CTRL_92 @0x170 {
    bytes 4;
        field pipe_lane0_cascaded_mpllb_sel {
            bits 1;
            reset 0x0;
            access rw;
        }
        field pipe_lane0_lanepll_bypass_mode @ 1 {
            bits 5;
            reset 0x1f;
            access rw;
        }
        field pipe_lane0_lanepll_src_sel @ 6 {
            bits 4;
            reset 0x0;
            access rw;
        }
        field pipe_lane0_ext_pll_mode @ 10 {
            bits 1;
            reset 0x0;
            access rw;
        }
        field pipe_lane0_destruct_rxmargin_mode @ 11 {
            bits 1;
            reset 0x0;
            access rw;
        }
        field pipe_lane1_cascaded_mpllb_sel @ 12 {
            bits 1;
            reset 0x0;
            access rw;
        }
        field pipe_lane1_lanepll_bypass_mode @ 13 {
            bits 5;
            reset 0x1f;
            access rw;
        }
        field pipe_lane1_lanepll_src_sel @ 18 {
            bits 4;
            reset 0x0;
            access rw;
        }
        field pipe_lane1_ext_pll_mode @ 22 {
            bits 1;
            reset 0x0;
            access rw;
        }
        field pipe_lane1_destruct_rxmargin_mode @ 23 {
            bits 1;
            reset 0x0;
            access rw;
        }
    }
    register PCIEPHY_CTRL_93 @0x174 {
    bytes 4;
        field pipe_lane2_cascaded_mpllb_sel {
            bits 1;
            reset 0x0;
            access rw;
        }
        field pipe_lane2_lanepll_bypass_mode @ 1 {
            bits 5;
            reset 0x1f;
            access rw;
        }
        field pipe_lane2_lanepll_src_sel @ 6 {
            bits 4;
            reset 0x0;
            access rw;
        }
        field pipe_lane2_ext_pll_mode @ 10 {
            bits 1;
            reset 0x0;
            access rw;
        }
        field pipe_lane2_destruct_rxmargin_mode @ 11 {
            bits 1;
            reset 0x0;
            access rw;
        }
        field pipe_lane3_cascaded_mpllb_sel @ 12 {
            bits 1;
            reset 0x0;
            access rw;
        }
        field pipe_lane3_lanepll_bypass_mode @ 13 {
            bits 5;
            reset 0x1f;
            access rw;
        }
        field pipe_lane3_lanepll_src_sel @ 18 {
            bits 4;
            reset 0x0;
            access rw;
        }
        field pipe_lane3_ext_pll_mode @ 22 {
            bits 1;
            reset 0x0;
            access rw;
        }
        field pipe_lane3_destruct_rxmargin_mode @ 23 {
            bits 1;
            reset 0x0;
            access rw;
        }
    }
    register PCIEPHY_CTRL_94 @0x178 {
    bytes 4;
        field pipe_lane4_cascaded_mpllb_sel {
            bits 1;
            reset 0x0;
            access rw;
        }
        field pipe_lane4_lanepll_bypass_mode @ 1 {
            bits 5;
            reset 0x1f;
            access rw;
        }
        field pipe_lane4_lanepll_src_sel @ 6 {
            bits 4;
            reset 0x0;
            access rw;
        }
        field pipe_lane4_ext_pll_mode @ 10 {
            bits 1;
            reset 0x0;
            access rw;
        }
        field pipe_lane4_destruct_rxmargin_mode @ 11 {
            bits 1;
            reset 0x0;
            access rw;
        }
        field pipe_lane5_cascaded_mpllb_sel @ 12 {
            bits 1;
            reset 0x0;
            access rw;
        }
        field pipe_lane5_lanepll_bypass_mode @ 13 {
            bits 5;
            reset 0x1f;
            access rw;
        }
        field pipe_lane5_lanepll_src_sel @ 18 {
            bits 4;
            reset 0x0;
            access rw;
        }
        field pipe_lane5_ext_pll_mode @ 22 {
            bits 1;
            reset 0x0;
            access rw;
        }
        field pipe_lane5_destruct_rxmargin_mode @ 23 {
            bits 1;
            reset 0x0;
            access rw;
        }
    }
    register PCIEPHY_CTRL_95 @0x17C {
    bytes 4;
        field pipe_lane6_cascaded_mpllb_sel {
            bits 1;
            reset 0x0;
            access rw;
        }
        field pipe_lane6_lanepll_bypass_mode @ 1 {
            bits 5;
            reset 0x1f;
            access rw;
        }
        field pipe_lane6_lanepll_src_sel @ 6 {
            bits 4;
            reset 0x0;
            access rw;
        }
        field pipe_lane6_ext_pll_mode @ 10 {
            bits 1;
            reset 0x0;
            access rw;
        }
        field pipe_lane6_destruct_rxmargin_mode @ 11 {
            bits 1;
            reset 0x0;
            access rw;
        }
        field pipe_lane7_cascaded_mpllb_sel @ 12 {
            bits 1;
            reset 0x0;
            access rw;
        }
        field pipe_lane7_lanepll_bypass_mode @ 13 {
            bits 5;
            reset 0x1f;
            access rw;
        }
        field pipe_lane7_lanepll_src_sel @ 18 {
            bits 4;
            reset 0x0;
            access rw;
        }
        field pipe_lane7_ext_pll_mode @ 22 {
            bits 1;
            reset 0x0;
            access rw;
        }
        field pipe_lane7_destruct_rxmargin_mode @ 23 {
            bits 1;
            reset 0x0;
            access rw;
        }
    }
    register PCIEPHY_CTRL_96 @0x180 {
    bytes 4;
        field pipe_lane8_cascaded_mpllb_sel {
            bits 1;
            reset 0x0;
            access rw;
        }
        field pipe_lane8_lanepll_bypass_mode @ 1 {
            bits 5;
            reset 0x1f;
            access rw;
        }
        field pipe_lane8_lanepll_src_sel @ 6 {
            bits 4;
            reset 0x0;
            access rw;
        }
        field pipe_lane8_ext_pll_mode @ 10 {
            bits 1;
            reset 0x0;
            access rw;
        }
        field pipe_lane8_destruct_rxmargin_mode @ 11 {
            bits 1;
            reset 0x0;
            access rw;
        }
        field pipe_lane9_cascaded_mpllb_sel @ 12 {
            bits 1;
            reset 0x0;
            access rw;
        }
        field pipe_lane9_lanepll_bypass_mode @ 13 {
            bits 5;
            reset 0x1f;
            access rw;
        }
        field pipe_lane9_lanepll_src_sel @ 18 {
            bits 4;
            reset 0x0;
            access rw;
        }
        field pipe_lane9_ext_pll_mode @ 22 {
            bits 1;
            reset 0x0;
            access rw;
        }
        field pipe_lane9_destruct_rxmargin_mode @ 23 {
            bits 1;
            reset 0x0;
            access rw;
        }
    }
    register PCIEPHY_CTRL_97 @0x184 {
    bytes 4;
        field pipe_lane10_cascaded_mpllb_sel {
            bits 1;
            reset 0x0;
            access rw;
        }
        field pipe_lane10_lanepll_bypass_mode @ 1 {
            bits 5;
            reset 0x1f;
            access rw;
        }
        field pipe_lane10_lanepll_src_sel @ 6 {
            bits 4;
            reset 0x0;
            access rw;
        }
        field pipe_lane10_ext_pll_mode @ 10 {
            bits 1;
            reset 0x0;
            access rw;
        }
        field pipe_lane10_destruct_rxmargin_mode @ 11 {
            bits 1;
            reset 0x0;
            access rw;
        }
        field pipe_lane11_cascaded_mpllb_sel @ 12 {
            bits 1;
            reset 0x0;
            access rw;
        }
        field pipe_lane11_lanepll_bypass_mode @ 13 {
            bits 5;
            reset 0x1f;
            access rw;
        }
        field pipe_lane11_lanepll_src_sel @ 18 {
            bits 4;
            reset 0x0;
            access rw;
        }
        field pipe_lane11_ext_pll_mode @ 22 {
            bits 1;
            reset 0x0;
            access rw;
        }
        field pipe_lane11_destruct_rxmargin_mode @ 23 {
            bits 1;
            reset 0x0;
            access rw;
        }
    }
    register PCIEPHY_CTRL_98 @0x188 {
    bytes 4;
        field pipe_lane12_cascaded_mpllb_sel {
            bits 1;
            reset 0x0;
            access rw;
        }
        field pipe_lane12_lanepll_bypass_mode @ 1 {
            bits 5;
            reset 0x1f;
            access rw;
        }
        field pipe_lane12_lanepll_src_sel @ 6 {
            bits 4;
            reset 0x0;
            access rw;
        }
        field pipe_lane12_ext_pll_mode @ 10 {
            bits 1;
            reset 0x0;
            access rw;
        }
        field pipe_lane12_destruct_rxmargin_mode @ 11 {
            bits 1;
            reset 0x0;
            access rw;
        }
        field pipe_lane13_cascaded_mpllb_sel @ 12 {
            bits 1;
            reset 0x0;
            access rw;
        }
        field pipe_lane13_lanepll_bypass_mode @ 13 {
            bits 5;
            reset 0x1f;
            access rw;
        }
        field pipe_lane13_lanepll_src_sel @ 18 {
            bits 4;
            reset 0x0;
            access rw;
        }
        field pipe_lane13_ext_pll_mode @ 22 {
            bits 1;
            reset 0x0;
            access rw;
        }
        field pipe_lane13_destruct_rxmargin_mode @ 23 {
            bits 1;
            reset 0x0;
            access rw;
        }
    }
    register PCIEPHY_CTRL_99 @0x18C {
    bytes 4;
        field pipe_lane14_cascaded_mpllb_sel {
            bits 1;
            reset 0x0;
            access rw;
        }
        field pipe_lane14_lanepll_bypass_mode @ 1 {
            bits 5;
            reset 0x1f;
            access rw;
        }
        field pipe_lane14_lanepll_src_sel @ 6 {
            bits 4;
            reset 0x0;
            access rw;
        }
        field pipe_lane14_ext_pll_mode @ 10 {
            bits 1;
            reset 0x0;
            access rw;
        }
        field pipe_lane14_destruct_rxmargin_mode @ 11 {
            bits 1;
            reset 0x0;
            access rw;
        }
        field pipe_lane15_cascaded_mpllb_sel @ 12 {
            bits 1;
            reset 0x0;
            access rw;
        }
        field pipe_lane15_lanepll_bypass_mode @ 13 {
            bits 5;
            reset 0x1f;
            access rw;
        }
        field pipe_lane15_lanepll_src_sel @ 18 {
            bits 4;
            reset 0x0;
            access rw;
        }
        field pipe_lane15_ext_pll_mode @ 22 {
            bits 1;
            reset 0x0;
            access rw;
        }
        field pipe_lane15_destruct_rxmargin_mode @ 23 {
            bits 1;
            reset 0x0;
            access rw;
        }
    }
    register PCIEPHY_CTRL_100 @0x190 {
    bytes 4;
        field pipe_rx0_rec_ovrd_en {
            bits 1;
            reset 0x0;
            access rw;
        }
        field pipe_rx0_rec_ovrd_8b10b_decerr @ 1 {
            bits 2;
            reset 0x0;
            access rw;
        }
        field pipe_rx0_rec_ovrd_8b10b_uoflow @ 3 {
            bits 2;
            reset 0x0;
            access rw;
        }
        field pipe_rx0_rec_ovrd_non8b10b_decerr @ 5 {
            bits 2;
            reset 0x0;
            access rw;
        }
        field pipe_rx0_rec_ovrd_non8b10b_uoflow @ 7 {
            bits 2;
            reset 0x0;
            access rw;
        }
        field pipe_rx0_eq_training @ 9 {
            bits 1;
            reset 0x0;
            access rw;
        }
        field pipe_rx1_rec_ovrd_en @ 10 {
            bits 1;
            reset 0x0;
            access rw;
        }
        field pipe_rx1_rec_ovrd_8b10b_decerr @ 11 {
            bits 2;
            reset 0x0;
            access rw;
        }
        field pipe_rx1_rec_ovrd_8b10b_uoflow @ 13 {
            bits 2;
            reset 0x0;
            access rw;
        }
        field pipe_rx1_rec_ovrd_non8b10b_decerr @ 15 {
            bits 2;
            reset 0x0;
            access rw;
        }
        field pipe_rx1_rec_ovrd_non8b10b_uoflow @ 17 {
            bits 2;
            reset 0x0;
            access rw;
        }
        field pipe_rx1_eq_training @ 19 {
            bits 1;
            reset 0x0;
            access rw;
        }
        field pipe_rx2_rec_ovrd_en @ 20 {
            bits 1;
            reset 0x0;
            access rw;
        }
        field pipe_rx2_rec_ovrd_8b10b_decerr @ 21 {
            bits 2;
            reset 0x0;
            access rw;
        }
        field pipe_rx2_rec_ovrd_8b10b_uoflow @ 23 {
            bits 2;
            reset 0x0;
            access rw;
        }
        field pipe_rx2_rec_ovrd_non8b10b_decerr @ 25 {
            bits 2;
            reset 0x0;
            access rw;
        }
        field pipe_rx2_rec_ovrd_non8b10b_uoflow @ 27 {
            bits 2;
            reset 0x0;
            access rw;
        }
        field pipe_rx2_eq_training @ 29 {
            bits 1;
            reset 0x0;
            access rw;
        }
    }
    register PCIEPHY_CTRL_101 @0x194 {
    bytes 4;
        field pipe_rx3_rec_ovrd_en {
            bits 1;
            reset 0x0;
            access rw;
        }
        field pipe_rx3_rec_ovrd_8b10b_decerr @ 1 {
            bits 2;
            reset 0x0;
            access rw;
        }
        field pipe_rx3_rec_ovrd_8b10b_uoflow @ 3 {
            bits 2;
            reset 0x0;
            access rw;
        }
        field pipe_rx3_rec_ovrd_non8b10b_decerr @ 5 {
            bits 2;
            reset 0x0;
            access rw;
        }
        field pipe_rx3_rec_ovrd_non8b10b_uoflow @ 7 {
            bits 2;
            reset 0x0;
            access rw;
        }
        field pipe_rx3_eq_training @ 9 {
            bits 1;
            reset 0x0;
            access rw;
        }
        field pipe_rx4_rec_ovrd_en @ 10 {
            bits 1;
            reset 0x0;
            access rw;
        }
        field pipe_rx4_rec_ovrd_8b10b_decerr @ 11 {
            bits 2;
            reset 0x0;
            access rw;
        }
        field pipe_rx4_rec_ovrd_8b10b_uoflow @ 13 {
            bits 2;
            reset 0x0;
            access rw;
        }
        field pipe_rx4_rec_ovrd_non8b10b_decerr @ 15 {
            bits 2;
            reset 0x0;
            access rw;
        }
        field pipe_rx4_rec_ovrd_non8b10b_uoflow @ 17 {
            bits 2;
            reset 0x0;
            access rw;
        }
        field pipe_rx4_eq_training @ 19 {
            bits 1;
            reset 0x0;
            access rw;
        }
        field pipe_rx5_rec_ovrd_en @ 20 {
            bits 1;
            reset 0x0;
            access rw;
        }
        field pipe_rx5_rec_ovrd_8b10b_decerr @ 21 {
            bits 2;
            reset 0x0;
            access rw;
        }
        field pipe_rx5_rec_ovrd_8b10b_uoflow @ 23 {
            bits 2;
            reset 0x0;
            access rw;
        }
        field pipe_rx5_rec_ovrd_non8b10b_decerr @ 25 {
            bits 2;
            reset 0x0;
            access rw;
        }
        field pipe_rx5_rec_ovrd_non8b10b_uoflow @ 27 {
            bits 2;
            reset 0x0;
            access rw;
        }
        field pipe_rx5_eq_training @ 29 {
            bits 1;
            reset 0x0;
            access rw;
        }
    }
    register PCIEPHY_CTRL_102 @0x198 {
    bytes 4;
        field pipe_rx6_rec_ovrd_en {
            bits 1;
            reset 0x0;
            access rw;
        }
        field pipe_rx6_rec_ovrd_8b10b_decerr @ 1 {
            bits 2;
            reset 0x0;
            access rw;
        }
        field pipe_rx6_rec_ovrd_8b10b_uoflow @ 3 {
            bits 2;
            reset 0x0;
            access rw;
        }
        field pipe_rx6_rec_ovrd_non8b10b_decerr @ 5 {
            bits 2;
            reset 0x0;
            access rw;
        }
        field pipe_rx6_rec_ovrd_non8b10b_uoflow @ 7 {
            bits 2;
            reset 0x0;
            access rw;
        }
        field pipe_rx6_eq_training @ 9 {
            bits 1;
            reset 0x0;
            access rw;
        }
        field pipe_rx7_rec_ovrd_en @ 10 {
            bits 1;
            reset 0x0;
            access rw;
        }
        field pipe_rx7_rec_ovrd_8b10b_decerr @ 11 {
            bits 2;
            reset 0x0;
            access rw;
        }
        field pipe_rx7_rec_ovrd_8b10b_uoflow @ 13 {
            bits 2;
            reset 0x0;
            access rw;
        }
        field pipe_rx7_rec_ovrd_non8b10b_decerr @ 15 {
            bits 2;
            reset 0x0;
            access rw;
        }
        field pipe_rx7_rec_ovrd_non8b10b_uoflow @ 17 {
            bits 2;
            reset 0x0;
            access rw;
        }
        field pipe_rx7_eq_training @ 19 {
            bits 1;
            reset 0x0;
            access rw;
        }
        field pipe_rx8_rec_ovrd_en @ 20 {
            bits 1;
            reset 0x0;
            access rw;
        }
        field pipe_rx8_rec_ovrd_8b10b_decerr @ 21 {
            bits 2;
            reset 0x0;
            access rw;
        }
        field pipe_rx8_rec_ovrd_8b10b_uoflow @ 23 {
            bits 2;
            reset 0x0;
            access rw;
        }
        field pipe_rx8_rec_ovrd_non8b10b_decerr @ 25 {
            bits 2;
            reset 0x0;
            access rw;
        }
        field pipe_rx8_rec_ovrd_non8b10b_uoflow @ 27 {
            bits 2;
            reset 0x0;
            access rw;
        }
        field pipe_rx8_eq_training @ 29 {
            bits 1;
            reset 0x0;
            access rw;
        }
    }
    register PCIEPHY_CTRL_103 @0x19C {
    bytes 4;
        field pipe_rx9_rec_ovrd_en {
            bits 1;
            reset 0x0;
            access rw;
        }
        field pipe_rx9_rec_ovrd_8b10b_decerr @ 1 {
            bits 2;
            reset 0x0;
            access rw;
        }
        field pipe_rx9_rec_ovrd_8b10b_uoflow @ 3 {
            bits 2;
            reset 0x0;
            access rw;
        }
        field pipe_rx9_rec_ovrd_non8b10b_decerr @ 5 {
            bits 2;
            reset 0x0;
            access rw;
        }
        field pipe_rx9_rec_ovrd_non8b10b_uoflow @ 7 {
            bits 2;
            reset 0x0;
            access rw;
        }
        field pipe_rx9_eq_training @ 9 {
            bits 1;
            reset 0x0;
            access rw;
        }
        field pipe_rx10_rec_ovrd_en @ 10 {
            bits 1;
            reset 0x0;
            access rw;
        }
        field pipe_rx10_rec_ovrd_8b10b_decerr @ 11 {
            bits 2;
            reset 0x0;
            access rw;
        }
        field pipe_rx10_rec_ovrd_8b10b_uoflow @ 13 {
            bits 2;
            reset 0x0;
            access rw;
        }
        field pipe_rx10_rec_ovrd_non8b10b_decerr @ 15 {
            bits 2;
            reset 0x0;
            access rw;
        }
        field pipe_rx10_rec_ovrd_non8b10b_uoflow @ 17 {
            bits 2;
            reset 0x0;
            access rw;
        }
        field pipe_rx10_eq_training @ 19 {
            bits 1;
            reset 0x0;
            access rw;
        }
        field pipe_rx11_rec_ovrd_en @ 20 {
            bits 1;
            reset 0x0;
            access rw;
        }
        field pipe_rx11_rec_ovrd_8b10b_decerr @ 21 {
            bits 2;
            reset 0x0;
            access rw;
        }
        field pipe_rx11_rec_ovrd_8b10b_uoflow @ 23 {
            bits 2;
            reset 0x0;
            access rw;
        }
        field pipe_rx11_rec_ovrd_non8b10b_decerr @ 25 {
            bits 2;
            reset 0x0;
            access rw;
        }
        field pipe_rx11_rec_ovrd_non8b10b_uoflow @ 27 {
            bits 2;
            reset 0x0;
            access rw;
        }
        field pipe_rx11_eq_training @ 29 {
            bits 1;
            reset 0x0;
            access rw;
        }
    }
    register PCIEPHY_CTRL_104 @0x1A0 {
    bytes 4;
        field pipe_rx12_rec_ovrd_en {
            bits 1;
            reset 0x0;
            access rw;
        }
        field pipe_rx12_rec_ovrd_8b10b_decerr @ 1 {
            bits 2;
            reset 0x0;
            access rw;
        }
        field pipe_rx12_rec_ovrd_8b10b_uoflow @ 3 {
            bits 2;
            reset 0x0;
            access rw;
        }
        field pipe_rx12_rec_ovrd_non8b10b_decerr @ 5 {
            bits 2;
            reset 0x0;
            access rw;
        }
        field pipe_rx12_rec_ovrd_non8b10b_uoflow @ 7 {
            bits 2;
            reset 0x0;
            access rw;
        }
        field pipe_rx12_eq_training @ 9 {
            bits 1;
            reset 0x0;
            access rw;
        }
        field pipe_rx13_rec_ovrd_en @ 10 {
            bits 1;
            reset 0x0;
            access rw;
        }
        field pipe_rx13_rec_ovrd_8b10b_decerr @ 11 {
            bits 2;
            reset 0x0;
            access rw;
        }
        field pipe_rx13_rec_ovrd_8b10b_uoflow @ 13 {
            bits 2;
            reset 0x0;
            access rw;
        }
        field pipe_rx13_rec_ovrd_non8b10b_decerr @ 15 {
            bits 2;
            reset 0x0;
            access rw;
        }
        field pipe_rx13_rec_ovrd_non8b10b_uoflow @ 17 {
            bits 2;
            reset 0x0;
            access rw;
        }
        field pipe_rx13_eq_training @ 19 {
            bits 1;
            reset 0x0;
            access rw;
        }
        field pipe_rx14_rec_ovrd_en @ 20 {
            bits 1;
            reset 0x0;
            access rw;
        }
        field pipe_rx14_rec_ovrd_8b10b_decerr @ 21 {
            bits 2;
            reset 0x0;
            access rw;
        }
        field pipe_rx14_rec_ovrd_8b10b_uoflow @ 23 {
            bits 2;
            reset 0x0;
            access rw;
        }
        field pipe_rx14_rec_ovrd_non8b10b_decerr @ 25 {
            bits 2;
            reset 0x0;
            access rw;
        }
        field pipe_rx14_rec_ovrd_non8b10b_uoflow @ 27 {
            bits 2;
            reset 0x0;
            access rw;
        }
        field pipe_rx14_eq_training @ 29 {
            bits 1;
            reset 0x0;
            access rw;
        }
    }
    register PCIEPHY_CTRL_105 @0x1A4 {
    bytes 4;
        field pipe_rx15_rec_ovrd_en {
            bits 1;
            reset 0x0;
            access rw;
        }
        field pipe_rx15_rec_ovrd_8b10b_decerr @ 1 {
            bits 2;
            reset 0x0;
            access rw;
        }
        field pipe_rx15_rec_ovrd_8b10b_uoflow @ 3 {
            bits 2;
            reset 0x0;
            access rw;
        }
        field pipe_rx15_rec_ovrd_non8b10b_decerr @ 5 {
            bits 2;
            reset 0x0;
            access rw;
        }
        field pipe_rx15_rec_ovrd_non8b10b_uoflow @ 7 {
            bits 2;
            reset 0x0;
            access rw;
        }
        field pipe_rx15_eq_training @ 9 {
            bits 1;
            reset 0x0;
            access rw;
        }
        field pipe_rx_es0_cmn_refclk_mode @ 10 {
            bits 1;
            reset 0x1;
            access rw;
        }
        field pipe_lane_legacy_pin_mode @ 11 {
            bits 1;
            reset 0x0;
            access rw;
        }
        field max_pclk_div_ratio_esm20 @ 12 {
            bits 5;
            reset 0x1;
            access rw;
        }
        field max_pclk_div_ratio_esm25 @ 17 {
            bits 5;
            reset 0x1;
            access rw;
        }
        field upcs_mpll_ssc_sync_mode @ 22 {
            bits 1;
            reset 0x0;
            access rw;
        }
    }
    register PCIEPHY_CTRL_106 @0x1A8 {
    bytes 4;
        field pipe_rx0_es_mode {
            bits 1;
            reset 0x0;
            access rw;
        }
        field pipe_rx1_es_mode @ 1 {
            bits 1;
            reset 0x0;
            access rw;
        }
        field pipe_rx2_es_mode @ 2 {
            bits 1;
            reset 0x0;
            access rw;
        }
        field pipe_rx3_es_mode @ 3 {
            bits 1;
            reset 0x0;
            access rw;
        }
        field pipe_rx4_es_mode @ 4 {
            bits 1;
            reset 0x0;
            access rw;
        }
        field pipe_rx5_es_mode @ 5 {
            bits 1;
            reset 0x0;
            access rw;
        }
        field pipe_rx6_es_mode @ 6 {
            bits 1;
            reset 0x0;
            access rw;
        }
        field pipe_rx7_es_mode @ 7 {
            bits 1;
            reset 0x0;
            access rw;
        }
        field pipe_rx8_es_mode @ 8 {
            bits 1;
            reset 0x0;
            access rw;
        }
        field pipe_rx9_es_mode @ 9 {
            bits 1;
            reset 0x0;
            access rw;
        }
        field pipe_rx10_es_mode @ 10 {
            bits 1;
            reset 0x0;
            access rw;
        }
        field pipe_rx11_es_mode @ 11 {
            bits 1;
            reset 0x0;
            access rw;
        }
        field pipe_rx12_es_mode @ 12 {
            bits 1;
            reset 0x0;
            access rw;
        }
        field pipe_rx13_es_mode @ 13 {
            bits 1;
            reset 0x0;
            access rw;
        }
        field pipe_rx14_es_mode @ 14 {
            bits 1;
            reset 0x0;
            access rw;
        }
        field pipe_rx15_es_mode @ 15 {
            bits 1;
            reset 0x0;
            access rw;
        }
    }
    register PCIEPHY_CTRL_107 @0x1AC {
    bytes 4;
        field phy_ext_ctrl_sel {
            bits 1;
            reset 0x0;
            access rw;
        }
        field protocol_ext_mplla_recal_bank_sel @ 1 {
            bits 2;
            reset 0x0;
            access rw;
        }
        field protocol_ext_mplla_recal_bank_sel_ovrd_en @ 3 {
            bits 1;
            reset 0x0;
            access rw;
        }
        field protocol_ext_mpllb_recal_bank_sel @ 4 {
            bits 2;
            reset 0x0;
            access rw;
        }
        field protocol_ext_mpllb_recal_bank_sel_ovrd_en @ 6 {
            bits 1;
            reset 0x0;
            access rw;
        }
    }
    register PCIEPHY_CTRL_108 @0x1B0 {
    bytes 4;
        field protocol_ext_phy0_mplla_bw_high {
            bits 16;
            reset 0x0;
            access rw;
        }
        field protocol_ext_phy0_mplla_bw_low @ 16 {
            bits 16;
            reset 0x0;
            access rw;
        }
    }
    register PCIEPHY_CTRL_109 @0x1B4 {
    bytes 4;
        field protocol_ext_phy0_mpllb_bw_high {
            bits 16;
            reset 0x0;
            access rw;
        }
        field protocol_ext_phy0_mpllb_bw_low @ 16 {
            bits 16;
            reset 0x0;
            access rw;
        }
    }
    register PCIEPHY_CTRL_110 @0x1B8 {
    bytes 4;
        field protocol_ext_phy1_mplla_bw_high {
            bits 16;
            reset 0x0;
            access rw;
        }
        field protocol_ext_phy1_mplla_bw_low @ 16 {
            bits 16;
            reset 0x0;
            access rw;
        }
    }
    register PCIEPHY_CTRL_111 @0x1BC {
    bytes 4;
        field protocol_ext_phy1_mpllb_bw_high {
            bits 16;
            reset 0x0;
            access rw;
        }
        field protocol_ext_phy1_mpllb_bw_low @ 16 {
            bits 16;
            reset 0x0;
            access rw;
        }
    }
    register PCIEPHY_CTRL_112 @0x1C0 {
    bytes 4;
        field protocol_ext_phy2_mplla_bw_high {
            bits 16;
            reset 0x0;
            access rw;
        }
        field protocol_ext_phy2_mplla_bw_low @ 16 {
            bits 16;
            reset 0x0;
            access rw;
        }
    }
    register PCIEPHY_CTRL_113 @0x1C4 {
    bytes 4;
        field protocol_ext_phy2_mpllb_bw_high {
            bits 16;
            reset 0x0;
            access rw;
        }
        field protocol_ext_phy2_mpllb_bw_low @ 16 {
            bits 16;
            reset 0x0;
            access rw;
        }
    }
    register PCIEPHY_CTRL_114 @0x1C8 {
    bytes 4;
        field protocol_ext_phy3_mplla_bw_high {
            bits 16;
            reset 0x0;
            access rw;
        }
        field protocol_ext_phy3_mplla_bw_low @ 16 {
            bits 16;
            reset 0x0;
            access rw;
        }
    }
    register PCIEPHY_CTRL_115 @0x1CC {
    bytes 4;
        field protocol_ext_phy3_mpllb_bw_high {
            bits 16;
            reset 0x0;
            access rw;
        }
        field protocol_ext_phy3_mpllb_bw_low @ 16 {
            bits 16;
            reset 0x0;
            access rw;
        }
    }
    register PCIEPHY_CTRL_116 @0x1D0 {
    bytes 4;
        field protocol_ext_phy0_mplla_bw_threshold {
            bits 8;
            reset 0x0;
            access rw;
        }
        field protocol_ext_phy0_mpllb_bw_threshold @ 8 {
            bits 8;
            reset 0x0;
            access rw;
        }
        field protocol_ext_phy1_mplla_bw_threshold @ 16 {
            bits 8;
            reset 0x0;
            access rw;
        }
        field protocol_ext_phy1_mpllb_bw_threshold @ 24 {
            bits 8;
            reset 0x0;
            access rw;
        }
    }
    register PCIEPHY_CTRL_117 @0x1D4 {
    bytes 4;
        field protocol_ext_phy2_mplla_bw_threshold {
            bits 8;
            reset 0x0;
            access rw;
        }
        field protocol_ext_phy2_mpllb_bw_threshold @ 8 {
            bits 8;
            reset 0x0;
            access rw;
        }
        field protocol_ext_phy3_mplla_bw_threshold @ 16 {
            bits 8;
            reset 0x0;
            access rw;
        }
        field protocol_ext_phy3_mpllb_bw_threshold @ 24 {
            bits 8;
            reset 0x0;
            access rw;
        }
    }
    register PCIEPHY_CTRL_118 @0x1D8 {
    bytes 4;
        field protocol_ext_phy0_mplla_tx_clk_div {
            bits 4;
            reset 0x0;
            access rw;
        }
        field protocol_ext_phy0_mpllb_tx_clk_div @ 4 {
            bits 4;
            reset 0x0;
            access rw;
        }
        field protocol_ext_phy1_mplla_tx_clk_div @ 8 {
            bits 4;
            reset 0x0;
            access rw;
        }
        field protocol_ext_phy1_mpllb_tx_clk_div @ 12 {
            bits 4;
            reset 0x0;
            access rw;
        }
        field protocol_ext_phy2_mplla_tx_clk_div @ 16 {
            bits 4;
            reset 0x0;
            access rw;
        }
        field protocol_ext_phy2_mpllb_tx_clk_div @ 20 {
            bits 4;
            reset 0x0;
            access rw;
        }
        field protocol_ext_phy3_mplla_tx_clk_div @ 24 {
            bits 4;
            reset 0x0;
            access rw;
        }
        field protocol_ext_phy3_mpllb_tx_clk_div @ 28 {
            bits 4;
            reset 0x0;
            access rw;
        }
    }
    register PCIEPHY_CTRL_119 @0x1DC {
    bytes 4;
        field protocol_ext_phy0_mplla_tx_clk_div_ovrd_en {
            bits 1;
            reset 0x0;
            access rw;
        }
        field protocol_ext_phy0_mpllb_tx_clk_div_ovrd_en @ 1 {
            bits 1;
            reset 0x0;
            access rw;
        }
        field protocol_ext_phy1_mplla_tx_clk_div_ovrd_en @ 2 {
            bits 1;
            reset 0x0;
            access rw;
        }
        field protocol_ext_phy1_mpllb_tx_clk_div_ovrd_en @ 3 {
            bits 1;
            reset 0x0;
            access rw;
        }
        field protocol_ext_phy2_mplla_tx_clk_div_ovrd_en @ 4 {
            bits 1;
            reset 0x0;
            access rw;
        }
        field protocol_ext_phy2_mpllb_tx_clk_div_ovrd_en @ 5 {
            bits 1;
            reset 0x0;
            access rw;
        }
        field protocol_ext_phy3_mplla_tx_clk_div_ovrd_en @ 6 {
            bits 1;
            reset 0x0;
            access rw;
        }
        field protocol_ext_phy3_mpllb_tx_clk_div_ovrd_en @ 7 {
            bits 1;
            reset 0x0;
            access rw;
        }
        field protocol_ext_rx_eq_afe_ovrd_en @ 8 {
            bits 1;
            reset 0x0;
            access rw;
        }
        field protocol_ext_rx_misc_ovrd_en @ 9 {
            bits 1;
            reset 0x0;
            access rw;
        }
        field protocol_ext_tx_ropll_ovrd_en @ 10 {
            bits 1;
            reset 0x0;
            access rw;
        }
        field protocol_ext_tx_ropll_postdiv_ovrd_en @ 11 {
            bits 16;
            reset 0x0;
            access rw;
        }
    }
    register PCIEPHY_CTRL_120 @0x1E0 {
    bytes 4;
        field protocol_ext_tx_ropll_refdiv_ovrd_en {
            bits 16;
            reset 0x0;
            access rw;
        }
        field protocol_ext_tx_ropll_word_clk_div_sel_ovrd_en @ 16 {
            bits 16;
            reset 0x0;
            access rw;
        }
    }
    register PCIEPHY_CTRL_121 @0x1E4 {
    bytes 4;
        field protocol0_ext_mplla_fb_clk_div4_en {
            bits 1;
            reset 0x0;
            access rw;
        }
        field protocol0_ext_mplla_frac_den @ 1 {
            bits 16;
            reset 0x0;
            access rw;
        }
        field protocol0_ext_mplla_frac_en @ 17 {
            bits 1;
            reset 0x0;
            access rw;
        }
        field protocol0_ext_mplla_multiplier @ 18 {
            bits 12;
            reset 0x0;
            access rw;
        }
        field protocol0_ext_mplla_word_clk_div @ 30 {
            bits 2;
            reset 0x0;
            access rw;
        }
    }
    register PCIEPHY_CTRL_122 @0x1E8 {
    bytes 4;
        field protocol0_ext_mplla_frac_quot {
            bits 16;
            reset 0x0;
            access rw;
        }
        field protocol0_ext_mplla_frac_rem @ 16 {
            bits 16;
            reset 0x0;
            access rw;
        }
    }
    register PCIEPHY_CTRL_123 @0x1EC {
    bytes 4;
        field protocol0_ext_mplla_multiplier {
            bits 12;
            reset 0x0;
            access rw;
        }
        field protocol0_ext_mplla_ssc_peak @ 12 {
            bits 20;
            reset 0x0;
            access rw;
        }
    }
    register PCIEPHY_CTRL_124 @0x1F0 {
    bytes 4;
        field protocol0_ext_mplla_ssc_step_size {
            bits 21;
            reset 0x0;
            access rw;
        }
        field protocol0_ext_mplla_ssc_up_spread @ 21 {
            bits 1;
            reset 0x0;
            access rw;
        }
    }
    register PCIEPHY_CTRL_125 @0x1F4 {
    bytes 4;
        field protocol0_ext_mpllb_fb_clk_div4_en {
            bits 1;
            reset 0x0;
            access rw;
        }
        field protocol0_ext_mpllb_frac_den @ 1 {
            bits 16;
            reset 0x0;
            access rw;
        }
        field protocol0_ext_mpllb_frac_en @ 17 {
            bits 1;
            reset 0x0;
            access rw;
        }
        field protocol0_ext_mpllb_multiplier @ 18 {
            bits 12;
            reset 0x0;
            access rw;
        }
        field protocol0_ext_mpllb_word_clk_div @ 30 {
            bits 2;
            reset 0x0;
            access rw;
        }
    }
    register PCIEPHY_CTRL_126 @0x1F8 {
    bytes 4;
        field protocol0_ext_mpllb_frac_quot {
            bits 16;
            reset 0x0;
            access rw;
        }
        field protocol0_ext_mpllb_frac_rem @ 16 {
            bits 16;
            reset 0x0;
            access rw;
        }
    }
    register PCIEPHY_CTRL_127 @0x1FC {
    bytes 4;
        field protocol0_ext_mpllb_multiplier {
            bits 12;
            reset 0x0;
            access rw;
        }
        field protocol0_ext_mpllb_ssc_peak @ 12 {
            bits 20;
            reset 0x0;
            access rw;
        }
    }
    register PCIEPHY_CTRL_128 @0x200 {
    bytes 4;
        field protocol0_ext_mpllb_ssc_step_size {
            bits 21;
            reset 0x0;
            access rw;
        }
        field protocol0_ext_mpllb_ssc_up_spread @ 21 {
            bits 1;
            reset 0x0;
            access rw;
        }
    }
    register PCIEPHY_CTRL_129 @0x204 {
    bytes 4;
        field protocol0_ext_ref_clk_mplla_div {
            bits 3;
            reset 0x0;
            access rw;
        }
        field protocol0_ext_ref_clk_mpllb_div @ 3 {
            bits 3;
            reset 0x0;
            access rw;
        }
    }
    register PCIEPHY_CTRL_130 @0x208 {
    bytes 4;
        field protocol0_ext_rx_adapt_mode_g1_31_0 {
            bits 32;
            reset 0x0;
            access rw;
        }
    }
    register PCIEPHY_CTRL_131 @0x20C {
    bytes 4;
        field protocol0_ext_rx_adapt_mode_g2_31_0 {
            bits 32;
            reset 0x0;
            access rw;
        }
    }
    register PCIEPHY_CTRL_132 @0x210 {
    bytes 4;
        field protocol0_ext_rx_adapt_mode_g3_31_0 {
            bits 32;
            reset 0x0;
            access rw;
        }
    }
    register PCIEPHY_CTRL_133 @0x214 {
    bytes 4;
        field protocol0_ext_rx_adapt_mode_g4_31_0 {
            bits 32;
            reset 0x0;
            access rw;
        }
    }
    register PCIEPHY_CTRL_134 @0x218 {
    bytes 4;
        field protocol0_ext_rx_adapt_mode_g5_31_0 {
            bits 32;
            reset 0x0;
            access rw;
        }
    }
    register PCIEPHY_CTRL_135 @0x21C {
    bytes 4;
        field protocol0_ext_rx_adapt_mode_g1_47_32 {
            bits 16;
            reset 0x0;
            access rw;
        }
        field protocol0_ext_rx_adapt_mode_g2_47_32 @ 16 {
            bits 16;
            reset 0x0;
            access rw;
        }
    }
    register PCIEPHY_CTRL_136 @0x220 {
    bytes 4;
        field protocol0_ext_rx_adapt_mode_g3_47_32 {
            bits 16;
            reset 0x0;
            access rw;
        }
        field protocol0_ext_rx_adapt_mode_g4_47_32 @ 16 {
            bits 16;
            reset 0x0;
            access rw;
        }
    }
    register PCIEPHY_CTRL_137 @0x224 {
    bytes 4;
        field protocol0_ext_rx_adapt_mode_g5_47_32 {
            bits 16;
            reset 0x0;
            access rw;
        }
    }
    register PCIEPHY_CTRL_138 @0x228 {
    bytes 4;
        field protocol0_ext_rx_adapt_sel_piperate0 {
            bits 32;
            reset 0x0;
            access rw;
        }
    }
    register PCIEPHY_CTRL_139 @0x22C {
    bytes 4;
        field protocol0_ext_rx_adapt_sel_piperate1 {
            bits 32;
            reset 0x0;
            access rw;
        }
    }
    register PCIEPHY_CTRL_140 @0x230 {
    bytes 4;
        field protocol0_ext_rx_adapt_sel_piperate2 {
            bits 32;
            reset 0x0;
            access rw;
        }
    }
    register PCIEPHY_CTRL_141 @0x234 {
    bytes 4;
        field protocol0_ext_rx_adapt_sel_piperate3 {
            bits 32;
            reset 0x0;
            access rw;
        }
    }
    register PCIEPHY_CTRL_142 @0x238 {
    bytes 4;
        field protocol0_ext_rx_adapt_sel_piperate4 {
            bits 32;
            reset 0x0;
            access rw;
        }
    }
    register PCIEPHY_CTRL_143 @0x23C {
    bytes 4;
        field protocol0_ext_rx_cdr_ppm_max_g1_31_0 {
            bits 32;
            reset 0x0;
            access rw;
        }
    }
    register PCIEPHY_CTRL_144 @0x240 {
    bytes 4;
        field protocol0_ext_rx_cdr_ppm_max_g1_63_32 {
            bits 32;
            reset 0x0;
            access rw;
        }
    }
    register PCIEPHY_CTRL_145 @0x244 {
    bytes 4;
        field protocol0_ext_rx_cdr_ppm_max_g2_31_0 {
            bits 32;
            reset 0x0;
            access rw;
        }
    }
    register PCIEPHY_CTRL_146 @0x248 {
    bytes 4;
        field protocol0_ext_rx_cdr_ppm_max_g2_63_32 {
            bits 32;
            reset 0x0;
            access rw;
        }
    }
    register PCIEPHY_CTRL_147 @0x24C {
    bytes 4;
        field protocol0_ext_rx_cdr_ppm_max_g3_31_0 {
            bits 32;
            reset 0x0;
            access rw;
        }
    }
    register PCIEPHY_CTRL_148 @0x250 {
    bytes 4;
        field protocol0_ext_rx_cdr_ppm_max_g3_63_32 {
            bits 32;
            reset 0x0;
            access rw;
        }
    }
    register PCIEPHY_CTRL_149 @0x254 {
    bytes 4;
        field protocol0_ext_rx_cdr_ppm_max_g4_31_0 {
            bits 32;
            reset 0x0;
            access rw;
        }
    }
    register PCIEPHY_CTRL_150 @0x258 {
    bytes 4;
        field protocol0_ext_rx_cdr_ppm_max_g4_63_32 {
            bits 32;
            reset 0x0;
            access rw;
        }
    }
    register PCIEPHY_CTRL_151 @0x25C {
    bytes 4;
        field protocol0_ext_rx_cdr_ppm_max_g5_31_0 {
            bits 32;
            reset 0x0;
            access rw;
        }
    }
    register PCIEPHY_CTRL_152 @0x260 {
    bytes 4;
        field protocol0_ext_rx_cdr_ppm_max_g5_63_32 {
            bits 32;
            reset 0x0;
            access rw;
        }
    }
    register PCIEPHY_CTRL_153 @0x264 {
    bytes 4;
        field protocol0_ext_rx_cdr_ppm_max_g2_79_64 {
            bits 16;
            reset 0x0;
            access rw;
        }
        field protocol0_ext_rx_cdr_ppm_max_g1_79_64 {
            bits 16;
            reset 0x0;
            access rw;
        }
    }
    register PCIEPHY_CTRL_154 @0x268 {
    bytes 4;
        field protocol0_ext_rx_cdr_ppm_max_g4_79_64 {
            bits 16;
            reset 0x0;
            access rw;
        }
        field protocol0_ext_rx_cdr_ppm_max_g3_79_64 {
            bits 16;
            reset 0x0;
            access rw;
        }
    }
    register PCIEPHY_CTRL_155 @0x26C {
    bytes 4;
        field protocol0_ext_rx_cdr_ppm_max_g5_79_64 {
            bits 16;
            reset 0x0;
            access rw;
        }
    }
    register PCIEPHY_CTRL_156 @0x270 {
    bytes 4;
        field protocol0_ext_rx_cdr_vco_config_g1_31_0 {
            bits 32;
            reset 0x0;
            access rw;
        }
    }
    register PCIEPHY_CTRL_157 @0x274 {
    bytes 4;
        field protocol0_ext_rx_cdr_vco_config_g1_63_32 {
            bits 32;
            reset 0x0;
            access rw;
        }
    }
    register PCIEPHY_CTRL_158 @0x278 {
    bytes 4;
        field protocol0_ext_rx_cdr_vco_config_g1_95_64 {
            bits 32;
            reset 0x0;
            access rw;
        }
    }
    register PCIEPHY_CTRL_159 @0x27C {
    bytes 4;
        field protocol0_ext_rx_cdr_vco_config_g1_127_96 {
            bits 32;
            reset 0x0;
            access rw;
        }
    }
    register PCIEPHY_CTRL_160 @0x280 {
    bytes 4;
        field protocol0_ext_rx_cdr_vco_config_g1_159_128 {
            bits 32;
            reset 0x0;
            access rw;
        }
    }
    register PCIEPHY_CTRL_161 @0x284 {
    bytes 4;
        field protocol0_ext_rx_cdr_vco_config_g1_191_160 {
            bits 32;
            reset 0x0;
            access rw;
        }
    }
    register PCIEPHY_CTRL_162 @0x288 {
    bytes 4;
        field protocol0_ext_rx_cdr_vco_config_g2_31_0 {
            bits 32;
            reset 0x0;
            access rw;
        }
    }
    register PCIEPHY_CTRL_163 @0x28C {
    bytes 4;
        field protocol0_ext_rx_cdr_vco_config_g2_63_32 {
            bits 32;
            reset 0x0;
            access rw;
        }
    }
    register PCIEPHY_CTRL_164 @0x290 {
    bytes 4;
        field protocol0_ext_rx_cdr_vco_config_g2_95_64 {
            bits 32;
            reset 0x0;
            access rw;
        }
    }
    register PCIEPHY_CTRL_165 @0x294 {
    bytes 4;
        field protocol0_ext_rx_cdr_vco_config_g2_127_96 {
            bits 32;
            reset 0x0;
            access rw;
        }
    }
    register PCIEPHY_CTRL_166 @0x298 {
    bytes 4;
        field protocol0_ext_rx_cdr_vco_config_g2_159_128 {
            bits 32;
            reset 0x0;
            access rw;
        }
    }
    register PCIEPHY_CTRL_167 @0x29C {
    bytes 4;
        field protocol0_ext_rx_cdr_vco_config_g2_191_160 {
            bits 32;
            reset 0x0;
            access rw;
        }
    }
    register PCIEPHY_CTRL_168 @0x2A0 {
    bytes 4;
        field protocol0_ext_rx_cdr_vco_config_g2_31_0 {
            bits 32;
            reset 0x0;
            access rw;
        }
    }
    register PCIEPHY_CTRL_169 @0x2A4 {
    bytes 4;
        field protocol0_ext_rx_cdr_vco_config_g2_63_32 {
            bits 32;
            reset 0x0;
            access rw;
        }
    }
    register PCIEPHY_CTRL_170 @0x2A8 {
    bytes 4;
        field protocol0_ext_rx_cdr_vco_config_g2_95_64 {
            bits 32;
            reset 0x0;
            access rw;
        }
    }
    register PCIEPHY_CTRL_171 @0x2AC {
    bytes 4;
        field protocol0_ext_rx_cdr_vco_config_g2_127_96 {
            bits 32;
            reset 0x0;
            access rw;
        }
    }
    register PCIEPHY_CTRL_172 @0x2B0 {
    bytes 4;
        field protocol0_ext_rx_cdr_vco_config_g2_159_128 {
            bits 32;
            reset 0x0;
            access rw;
        }
    }
    register PCIEPHY_CTRL_173 @0x2B4 {
    bytes 4;
        field protocol0_ext_rx_cdr_vco_config_g2_191_160 {
            bits 32;
            reset 0x0;
            access rw;
        }
    }
    register PCIEPHY_CTRL_174 @0x2B8 {
    bytes 4;
        field protocol0_ext_rx_cdr_vco_config_g3_31_0 {
            bits 32;
            reset 0x0;
            access rw;
        }
    }
    register PCIEPHY_CTRL_175 @0x2BC {
    bytes 4;
        field protocol0_ext_rx_cdr_vco_config_g3_63_32 {
            bits 32;
            reset 0x0;
            access rw;
        }
    }
    register PCIEPHY_CTRL_176 @0x2C0 {
    bytes 4;
        field protocol0_ext_rx_cdr_vco_config_g3_95_64 {
            bits 32;
            reset 0x0;
            access rw;
        }
    }
    register PCIEPHY_CTRL_177 @0x2C4 {
    bytes 4;
        field protocol0_ext_rx_cdr_vco_config_g3_127_96 {
            bits 32;
            reset 0x0;
            access rw;
        }
    }
    register PCIEPHY_CTRL_178 @0x2C8 {
    bytes 4;
        field protocol0_ext_rx_cdr_vco_config_g3_159_128 {
            bits 32;
            reset 0x0;
            access rw;
        }
    }
    register PCIEPHY_CTRL_179 @0x2CC {
    bytes 4;
        field protocol0_ext_rx_cdr_vco_config_g3_191_160 {
            bits 32;
            reset 0x0;
            access rw;
        }
    }
    register PCIEPHY_CTRL_180 @0x2D0 {
    bytes 4;
        field protocol0_ext_rx_cdr_vco_config_g4_31_0 {
            bits 32;
            reset 0x0;
            access rw;
        }
    }
    register PCIEPHY_CTRL_181 @0x2D4 {
    bytes 4;
        field protocol0_ext_rx_cdr_vco_config_g4_63_32 {
            bits 32;
            reset 0x0;
            access rw;
        }
    }
    register PCIEPHY_CTRL_182 @0x2D8 {
    bytes 4;
        field protocol0_ext_rx_cdr_vco_config_g4_95_64 {
            bits 32;
            reset 0x0;
            access rw;
        }
    }
    register PCIEPHY_CTRL_183 @0x2DC {
    bytes 4;
        field protocol0_ext_rx_cdr_vco_config_g4_127_96 {
            bits 32;
            reset 0x0;
            access rw;
        }
    }
    register PCIEPHY_CTRL_184 @0x2E0 {
    bytes 4;
        field protocol0_ext_rx_cdr_vco_config_g4_159_128 {
            bits 32;
            reset 0x0;
            access rw;
        }
    }
    register PCIEPHY_CTRL_185 @0x2E4 {
    bytes 4;
        field protocol0_ext_rx_cdr_vco_config_g4_191_160 {
            bits 32;
            reset 0x0;
            access rw;
        }
    }
    register PCIEPHY_CTRL_186 @0x2E8 {
    bytes 4;
        field protocol0_ext_rx_cdr_vco_config_g5_31_0 {
            bits 32;
            reset 0x0;
            access rw;
        }
    }
    register PCIEPHY_CTRL_187 @0x2EC {
    bytes 4;
        field protocol0_ext_rx_cdr_vco_config_g5_63_32 {
            bits 32;
            reset 0x0;
            access rw;
        }
    }
    register PCIEPHY_CTRL_188 @0x2F0 {
    bytes 4;
        field protocol0_ext_rx_cdr_vco_config_g5_95_64 {
            bits 32;
            reset 0x0;
            access rw;
        }
    }
    register PCIEPHY_CTRL_189 @0x2F4 {
    bytes 4;
        field protocol0_ext_rx_cdr_vco_config_g5_127_96 {
            bits 32;
            reset 0x0;
            access rw;
        }
    }
    register PCIEPHY_CTRL_190 @0x2F8 {
    bytes 4;
        field protocol0_ext_rx_cdr_vco_config_g5_159_128 {
            bits 32;
            reset 0x0;
            access rw;
        }
    }
    register PCIEPHY_CTRL_191 @0x2FC {
    bytes 4;
        field protocol0_ext_rx_cdr_vco_config_g5_191_160 {
            bits 32;
            reset 0x0;
            access rw;
        }
    }
    register PCIEPHY_CTRL_192 @0x300 {
    bytes 4;
        field protocol0_ext_rx_dcc_ctrl_cm_range_g1 {
            bits 4;
            reset 0x0;
            access rw;
        }
        field protocol0_ext_rx_dcc_ctrl_cm_range_g2 @ 4 {
            bits 4;
            reset 0x0;
            access rw;
        }
        field protocol0_ext_rx_dcc_ctrl_cm_range_g3 @ 8 {
            bits 4;
            reset 0x0;
            access rw;
        }
        field protocol0_ext_rx_dcc_ctrl_cm_range_g4 @ 12 {
            bits 4;
            reset 0x0;
            access rw;
        }
        field protocol0_ext_rx_dcc_ctrl_cm_range_g5 @ 16 {
            bits 4;
            reset 0x0;
            access rw;
        }
        field protocol0_ext_rx_dcc_ctrl_diff_range_g1 @ 20 {
            bits 4;
            reset 0x0;
            access rw;
        }
        field protocol0_ext_rx_dcc_ctrl_diff_range_g2 @ 24 {
            bits 4;
            reset 0x0;
            access rw;
        }
        field protocol0_ext_rx_dcc_ctrl_diff_range_g3 @ 28 {
            bits 4;
            reset 0x0;
            access rw;
        }
    }
    register PCIEPHY_CTRL_193 @0x304 {
    bytes 4;
        field protocol0_ext_rx_dcc_ctrl_diff_range_g4 {
            bits 4;
            reset 0x0;
            access rw;
        }
        field protocol0_ext_rx_dcc_ctrl_diff_range_g5 @ 4 {
            bits 4;
            reset 0x0;
            access rw;
        }
    }
    register PCIEPHY_CTRL_194 @0x308 {
    bytes 4;
        field protocol0_ext_rx_delta_iq_g1_31_0 {
            bits 32;
            reset 0x0;
            access rw;
        }
    }
    register PCIEPHY_CTRL_195 @0x30C {
    bytes 4;
        field protocol0_ext_rx_delta_iq_g1_63_32 {
            bits 32;
            reset 0x0;
            access rw;
        }
    }
    register PCIEPHY_CTRL_196 @0x310 {
    bytes 4;
        field protocol0_ext_rx_delta_iq_g2_31_0 {
            bits 32;
            reset 0x0;
            access rw;
        }
    }
    register PCIEPHY_CTRL_197 @0x314 {
    bytes 4;
        field protocol0_ext_rx_delta_iq_g2_63_32 {
            bits 32;
            reset 0x0;
            access rw;
        }
    }
    register PCIEPHY_CTRL_198 @0x318 {
    bytes 4;
        field protocol0_ext_rx_delta_iq_g3_31_0 {
            bits 32;
            reset 0x0;
            access rw;
        }
    }
    register PCIEPHY_CTRL_199 @0x31C {
    bytes 4;
        field protocol0_ext_rx_delta_iq_g3_63_32 {
            bits 32;
            reset 0x0;
            access rw;
        }
    }
    register PCIEPHY_CTRL_200 @0x320 {
    bytes 4;
        field protocol0_ext_rx_delta_iq_g4_31_0 {
            bits 32;
            reset 0x0;
            access rw;
        }
    }
    register PCIEPHY_CTRL_201 @0x324 {
    bytes 4;
        field protocol0_ext_rx_delta_iq_g4_63_32 {
            bits 32;
            reset 0x0;
            access rw;
        }
    }
    register PCIEPHY_CTRL_202 @0x328 {
    bytes 4;
        field protocol0_ext_rx_delta_iq_g5_31_0 {
            bits 32;
            reset 0x0;
            access rw;
        }
    }
    register PCIEPHY_CTRL_203 @0x32C {
    bytes 4;
        field protocol0_ext_rx_delta_iq_g5_63_32 {
            bits 32;
            reset 0x0;
            access rw;
        }
    }
    register PCIEPHY_CTRL_204 @0x330 {
    bytes 4;
        field protocol0_ext_rx_dfe_bypass_g1 {
            bits 16;
            reset 0x0;
            access rw;
        }
        field protocol0_ext_rx_dfe_bypass_g2 @ 16 {
            bits 16;
            reset 0x0;
            access rw;
        }
    }
    register PCIEPHY_CTRL_205 @0x334 {
    bytes 4;
        field protocol0_ext_rx_dfe_bypass_g3 {
            bits 16;
            reset 0x0;
            access rw;
        }
        field protocol0_ext_rx_dfe_bypass_g4 @ 16 {
            bits 16;
            reset 0x0;
            access rw;
        }
    }
    register PCIEPHY_CTRL_206 @0x338 {
    bytes 4;
        field protocol0_ext_rx_dfe_bypass_g5 {
            bits 16;
            reset 0x0;
            access rw;
        }
    }
    register PCIEPHY_CTRL_207 @0x33C {
    bytes 4;
        field protocol0_ext_rx_eq_afe_config_g1_31_0 {
            bits 32;
            reset 0x0;
            access rw;
        }
    }
    register PCIEPHY_CTRL_208 @0x340 {
    bytes 4;
        field protocol0_ext_rx_eq_afe_config_g1_63_32 {
            bits 32;
            reset 0x0;
            access rw;
        }
    }
    register PCIEPHY_CTRL_209 @0x344 {
    bytes 4;
        field protocol0_ext_rx_eq_afe_config_g1_95_64 {
            bits 32;
            reset 0x0;
            access rw;
        }
    }
    register PCIEPHY_CTRL_210 @0x348 {
    bytes 4;
        field protocol0_ext_rx_eq_afe_config_g1_127_96 {
            bits 32;
            reset 0x0;
            access rw;
        }
    }
    register PCIEPHY_CTRL_211 @0x34C {
    bytes 4;
        field protocol0_ext_rx_eq_afe_config_g1_159_128 {
            bits 32;
            reset 0x0;
            access rw;
        }
    }
    register PCIEPHY_CTRL_212 @0x350 {
    bytes 4;
        field protocol0_ext_rx_eq_afe_config_g1_191_160 {
            bits 32;
            reset 0x0;
            access rw;
        }
    }
    register PCIEPHY_CTRL_213 @0x354 {
    bytes 4;
        field protocol0_ext_rx_eq_afe_config_g2_31_0 {
            bits 32;
            reset 0x0;
            access rw;
        }
    }
    register PCIEPHY_CTRL_214 @0x358 {
    bytes 4;
        field protocol0_ext_rx_eq_afe_config_g2_63_32 {
            bits 32;
            reset 0x0;
            access rw;
        }
    }
    register PCIEPHY_CTRL_215 @0x35C {
    bytes 4;
        field protocol0_ext_rx_eq_afe_config_g2_95_64 {
            bits 32;
            reset 0x0;
            access rw;
        }
    }
    register PCIEPHY_CTRL_216 @0x360 {
    bytes 4;
        field protocol0_ext_rx_eq_afe_config_g2_127_96 {
            bits 32;
            reset 0x0;
            access rw;
        }
    }
    register PCIEPHY_CTRL_217 @0x364 {
    bytes 4;
        field protocol0_ext_rx_eq_afe_config_g2_159_128 {
            bits 32;
            reset 0x0;
            access rw;
        }
    }
    register PCIEPHY_CTRL_218 @0x368 {
    bytes 4;
        field protocol0_ext_rx_eq_afe_config_g2_191_160 {
            bits 32;
            reset 0x0;
            access rw;
        }
    }
    register PCIEPHY_CTRL_219 @0x36C {
    bytes 4;
        field protocol0_ext_rx_eq_afe_config_g3_31_0 {
            bits 32;
            reset 0x0;
            access rw;
        }
    }
    register PCIEPHY_CTRL_220 @0x370 {
    bytes 4;
        field protocol0_ext_rx_eq_afe_config_g3_63_32 {
            bits 32;
            reset 0x0;
            access rw;
        }
    }
    register PCIEPHY_CTRL_221 @0x374 {
    bytes 4;
        field protocol0_ext_rx_eq_afe_config_g3_95_64 {
            bits 32;
            reset 0x0;
            access rw;
        }
    }
    register PCIEPHY_CTRL_222 @0x378 {
    bytes 4;
        field protocol0_ext_rx_eq_afe_config_g3_127_96 {
            bits 32;
            reset 0x0;
            access rw;
        }
    }
    register PCIEPHY_CTRL_223 @0x37C {
    bytes 4;
        field protocol0_ext_rx_eq_afe_config_g3_159_128 {
            bits 32;
            reset 0x0;
            access rw;
        }
    }
    register PCIEPHY_CTRL_224 @0x380 {
    bytes 4;
        field protocol0_ext_rx_eq_afe_config_g3_191_160 {
            bits 32;
            reset 0x0;
            access rw;
        }
    }
    register PCIEPHY_CTRL_225 @0x384 {
    bytes 4;
        field protocol0_ext_rx_eq_afe_config_g4_31_0 {
            bits 32;
            reset 0x0;
            access rw;
        }
    }
    register PCIEPHY_CTRL_226 @0x388 {
    bytes 4;
        field protocol0_ext_rx_eq_afe_config_g4_63_32 {
            bits 32;
            reset 0x0;
            access rw;
        }
    }
    register PCIEPHY_CTRL_227 @0x38C {
    bytes 4;
        field protocol0_ext_rx_eq_afe_config_g4_95_64 {
            bits 32;
            reset 0x0;
            access rw;
        }
    }
    register PCIEPHY_CTRL_228 @0x390 {
    bytes 4;
        field protocol0_ext_rx_eq_afe_config_g4_127_96 {
            bits 32;
            reset 0x0;
            access rw;
        }
    }
    register PCIEPHY_CTRL_229 @0x394 {
    bytes 4;
        field protocol0_ext_rx_eq_afe_config_g4_159_128 {
            bits 32;
            reset 0x0;
            access rw;
        }
    }
    register PCIEPHY_CTRL_230 @0x398 {
    bytes 4;
        field protocol0_ext_rx_eq_afe_config_g4_191_160 {
            bits 32;
            reset 0x0;
            access rw;
        }
    }
    register PCIEPHY_CTRL_231 @0x39C {
    bytes 4;
        field protocol0_ext_rx_eq_afe_config_g5_31_0 {
            bits 32;
            reset 0x0;
            access rw;
        }
    }
    register PCIEPHY_CTRL_232 @0x3A0 {
    bytes 4;
        field protocol0_ext_rx_eq_afe_config_g5_63_32 {
            bits 32;
            reset 0x0;
            access rw;
        }
    }
    register PCIEPHY_CTRL_233 @0x3A4 {
    bytes 4;
        field protocol0_ext_rx_eq_afe_config_g5_95_64 {
            bits 32;
            reset 0x0;
            access rw;
        }
    }
    register PCIEPHY_CTRL_234 @0x3A8 {
    bytes 4;
        field protocol0_ext_rx_eq_afe_config_g5_127_96 {
            bits 32;
            reset 0x0;
            access rw;
        }
    }
    register PCIEPHY_CTRL_235 @0x3AC {
    bytes 4;
        field protocol0_ext_rx_eq_afe_config_g5_159_128 {
            bits 32;
            reset 0x0;
            access rw;
        }
    }
    register PCIEPHY_CTRL_236 @0x3B0 {
    bytes 4;
        field protocol0_ext_rx_eq_afe_config_g5_191_160 {
            bits 32;
            reset 0x0;
            access rw;
        }
    }
    register PCIEPHY_CTRL_237 @0x3B4 {
    bytes 4;
        field protocol0_ext_rx_eq_afe_rate_g1_31_0 {
            bits 32;
            reset 0x0;
            access rw;
        }
    }
    register PCIEPHY_CTRL_238 @0x3B8 {
    bytes 4;
        field protocol0_ext_rx_eq_afe_rate_g2_31_0 {
            bits 32;
            reset 0x0;
            access rw;
        }
    }
    register PCIEPHY_CTRL_239 @0x3BC {
    bytes 4;
        field protocol0_ext_rx_eq_afe_rate_g3_31_0 {
            bits 32;
            reset 0x0;
            access rw;
        }
    }
    register PCIEPHY_CTRL_240 @0x3C0 {
    bytes 4;
        field protocol0_ext_rx_eq_afe_rate_g4_31_0 {
            bits 32;
            reset 0x0;
            access rw;
        }
    }
    register PCIEPHY_CTRL_241 @0x3C4 {
    bytes 4;
        field protocol0_ext_rx_eq_afe_rate_g5_31_0 {
            bits 32;
            reset 0x0;
            access rw;
        }
    }
    register PCIEPHY_CTRL_242 @0x3C8 {
    bytes 4;
        field protocol0_ext_rx_eq_afe_rate_g1_47_32 {
            bits 16;
            reset 0x0;
            access rw;
        }
        field protocol0_ext_rx_eq_afe_rate_g2_47_32 @ 16 {
            bits 16;
            reset 0x0;
            access rw;
        }
    }
    register PCIEPHY_CTRL_243 @0x3CC {
    bytes 4;
        field protocol0_ext_rx_eq_afe_rate_g3_47_32 {
            bits 16;
            reset 0x0;
            access rw;
        }
        field protocol0_ext_rx_eq_afe_rate_g4_47_32 @ 16 {
            bits 16;
            reset 0x0;
            access rw;
        }
    }
    register PCIEPHY_CTRL_244 @0x3D0 {
    bytes 4;
        field protocol0_ext_rx_eq_afe_rate_g5_47_32 {
            bits 16;
            reset 0x0;
            access rw;
        }
    }
    register PCIEPHY_CTRL_245 @0x3D4 {
    bytes 4;
        field protocol0_ext_rx_eq_att_lvl_g1_31_0 {
            bits 32;
            reset 0x0;
            access rw;
        }
    }
    register PCIEPHY_CTRL_246 @0x3D8 {
    bytes 4;
        field protocol0_ext_rx_eq_att_lvl_g2_31_0 {
            bits 32;
            reset 0x0;
            access rw;
        }
    }
    register PCIEPHY_CTRL_247 @0x3DC {
    bytes 4;
        field protocol0_ext_rx_eq_att_lvl_g2_31_0 {
            bits 32;
            reset 0x0;
            access rw;
        }
    }
    register PCIEPHY_CTRL_248 @0x3E0 {
    bytes 4;
        field protocol0_ext_rx_eq_att_lvl_g2_31_0 {
            bits 32;
            reset 0x0;
            access rw;
        }
    }
    register PCIEPHY_CTRL_249 @0x3E4 {
    bytes 4;
        field protocol0_ext_rx_eq_att_lvl_g2_31_0 {
            bits 32;
            reset 0x0;
            access rw;
        }
    }
    register PCIEPHY_CTRL_250 @0x3E8 {
    bytes 4;
        field protocol0_ext_rx_eq_att_lvl_g1_47_32 {
            bits 16;
            reset 0x0;
            access rw;
        }
        field protocol0_ext_rx_eq_att_lvl_g2_47_32 @ 16 {
            bits 16;
            reset 0x0;
            access rw;
        }
    }
    register PCIEPHY_CTRL_251 @0x3EC {
    bytes 4;
        field protocol0_ext_rx_eq_att_lvl_g3_47_32 {
            bits 16;
            reset 0x0;
            access rw;
        }
        field protocol0_ext_rx_eq_att_lvl_g4_47_32 @ 16 {
            bits 16;
            reset 0x0;
            access rw;
        }
    }
    register PCIEPHY_CTRL_252 @0x3F0 {
    bytes 4;
        field protocol0_ext_rx_eq_att_lvl_g5_47_32 {
            bits 16;
            reset 0x0;
            access rw;
        }
    }
    register PCIEPHY_CTRL_253 @0x3F4 {
    bytes 4;
        field protocol0_ext_rx_eq_ctle_boost_g1_31_0 {
            bits 32;
            reset 0x0;
            access rw;
        }
    }
    register PCIEPHY_CTRL_254 @0x3F8 {
    bytes 4;
        field protocol0_ext_rx_eq_ctle_boost_g1_63_32 {
            bits 32;
            reset 0x0;
            access rw;
        }
    }
    register PCIEPHY_CTRL_255 @0x3FC {
    bytes 4;
        field protocol0_ext_rx_eq_ctle_boost_g2_31_0 {
            bits 32;
            reset 0x0;
            access rw;
        }
    }
    register PCIEPHY_CTRL_256 @0x400 {
    bytes 4;
        field protocol0_ext_rx_eq_ctle_boost_g2_63_32 {
            bits 32;
            reset 0x0;
            access rw;
        }
    }
    register PCIEPHY_CTRL_257 @0x404 {
    bytes 4;
        field protocol0_ext_rx_eq_ctle_boost_g3_31_0 {
            bits 32;
            reset 0x0;
            access rw;
        }
    }
    register PCIEPHY_CTRL_258 @0x408 {
    bytes 4;
        field protocol0_ext_rx_eq_ctle_boost_g3_63_32 {
            bits 32;
            reset 0x0;
            access rw;
        }
    }
    register PCIEPHY_CTRL_259 @0x40C {
    bytes 4;
        field protocol0_ext_rx_eq_ctle_boost_g4_31_0 {
            bits 32;
            reset 0x0;
            access rw;
        }
    }
    register PCIEPHY_CTRL_260 @0x410 {
    bytes 4;
        field protocol0_ext_rx_eq_ctle_boost_g4_63_32 {
            bits 32;
            reset 0x0;
            access rw;
        }
    }
    register PCIEPHY_CTRL_261 @0x414 {
    bytes 4;
        field protocol0_ext_rx_eq_ctle_boost_g5_31_0 {
            bits 32;
            reset 0x0;
            access rw;
        }
    }
    register PCIEPHY_CTRL_262 @0x418 {
    bytes 4;
        field protocol0_ext_rx_eq_ctle_boost_g5_63_32 {
            bits 32;
            reset 0x0;
            access rw;
        }
    }
    register PCIEPHY_CTRL_263 @0x41C {
    bytes 4;
        field protocol0_ext_rx_eq_ctle_boost_g1_79_64 {
            bits 16;
            reset 0x0;
            access rw;
        }
        field protocol0_ext_rx_eq_ctle_boost_g2_79_64 @ 16 {
            bits 16;
            reset 0x0;
            access rw;
        }
    }
    register PCIEPHY_CTRL_264 @0x420 {
    bytes 4;
        field protocol0_ext_rx_eq_ctle_boost_g3_79_64 {
            bits 16;
            reset 0x0;
            access rw;
        }
        field protocol0_ext_rx_eq_ctle_boost_g4_79_64 @ 16 {
            bits 16;
            reset 0x0;
            access rw;
        }
    }
    register PCIEPHY_CTRL_265 @0x424 {
    bytes 4;
        field protocol0_ext_rx_eq_ctle_boost_g5_79_64 {
            bits 16;
            reset 0x0;
            access rw;
        }
    }
    register PCIEPHY_CTRL_266 @0x428 {
    bytes 4;
        field protocol0_ext_rx_eq_ctle_pole_g1 {
            bits 32;
            reset 0x0;
            access rw;
        }
    }
    register PCIEPHY_CTRL_267 @0x42C {
    bytes 4;
        field protocol0_ext_rx_eq_ctle_pole_g2 {
            bits 32;
            reset 0x0;
            access rw;
        }
    }
    register PCIEPHY_CTRL_268 @0x430 {
    bytes 4;
        field protocol0_ext_rx_eq_ctle_pole_g3 {
            bits 32;
            reset 0x0;
            access rw;
        }
    }
    register PCIEPHY_CTRL_269 @0x434 {
    bytes 4;
        field protocol0_ext_rx_eq_ctle_pole_g4 {
            bits 32;
            reset 0x0;
            access rw;
        }
    }
    register PCIEPHY_CTRL_270 @0x438 {
    bytes 4;
        field protocol0_ext_rx_eq_ctle_pole_g5 {
            bits 32;
            reset 0x0;
            access rw;
        }
    }
    register PCIEPHY_CTRL_271 @0x43C {
    bytes 4;
        field protocol0_ext_rx_eq_dfe_float_en_g1 {
            bits 16;
            reset 0x0;
            access rw;
        }
        field protocol0_ext_rx_eq_dfe_float_en_g2 @ 16 {
            bits 16;
            reset 0x0;
            access rw;
        }
    }
    register PCIEPHY_CTRL_272 @0x440 {
    bytes 4;
        field protocol0_ext_rx_eq_dfe_float_en_g3 {
            bits 16;
            reset 0x0;
            access rw;
        }
        field protocol0_ext_rx_eq_dfe_float_en_g4 @ 16 {
            bits 16;
            reset 0x0;
            access rw;
        }
    }
    register PCIEPHY_CTRL_273 @0x444 {
    bytes 4;
        field protocol0_ext_rx_eq_dfe_float_en_g5 {
            bits 16;
            reset 0x0;
            access rw;
        }
    }
    register PCIEPHY_CTRL_274 @0x448 {
    bytes 4;
        field protocol0_ext_rx_eq_dfe_tap1_g1_31_0 {
            bits 32;
            reset 0x0;
            access rw;
        }
    }
    register PCIEPHY_CTRL_275 @0x44C {
    bytes 4;
        field protocol0_ext_rx_eq_dfe_tap1_g1_63_32 {
            bits 32;
            reset 0x0;
            access rw;
        }
    }
    register PCIEPHY_CTRL_276 @0x450 {
    bytes 4;
        field protocol0_ext_rx_eq_dfe_tap1_g1_95_64 {
            bits 32;
            reset 0x0;
            access rw;
        }
    }
    register PCIEPHY_CTRL_277 @0x454 {
    bytes 4;
        field protocol0_ext_rx_eq_dfe_tap1_g1_127_96 {
            bits 32;
            reset 0x0;
            access rw;
        }
    }
    register PCIEPHY_CTRL_278 @0x458 {
    bytes 4;
        field protocol0_ext_rx_eq_dfe_tap1_g2_31_0 {
            bits 32;
            reset 0x0;
            access rw;
        }
    }
    register PCIEPHY_CTRL_279 @0x45C {
    bytes 4;
        field protocol0_ext_rx_eq_dfe_tap1_g2_63_32 {
            bits 32;
            reset 0x0;
            access rw;
        }
    }
    register PCIEPHY_CTRL_280 @0x460 {
    bytes 4;
        field protocol0_ext_rx_eq_dfe_tap1_g2_95_64 {
            bits 32;
            reset 0x0;
            access rw;
        }
    }
    register PCIEPHY_CTRL_281 @0x464 {
    bytes 4;
        field protocol0_ext_rx_eq_dfe_tap1_g2_127_96 {
            bits 32;
            reset 0x0;
            access rw;
        }
    }
    register PCIEPHY_CTRL_282 @0x468 {
    bytes 4;
        field protocol0_ext_rx_eq_dfe_tap1_g3_31_0 {
            bits 32;
            reset 0x0;
            access rw;
        }
    }
    register PCIEPHY_CTRL_283 @0x46C {
    bytes 4;
        field protocol0_ext_rx_eq_dfe_tap1_g3_63_32 {
            bits 32;
            reset 0x0;
            access rw;
        }
    }
    register PCIEPHY_CTRL_284 @0x470 {
    bytes 4;
        field protocol0_ext_rx_eq_dfe_tap1_g3_95_64 {
            bits 32;
            reset 0x0;
            access rw;
        }
    }
    register PCIEPHY_CTRL_285 @0x474 {
    bytes 4;
        field protocol0_ext_rx_eq_dfe_tap1_g3_127_96 {
            bits 32;
            reset 0x0;
            access rw;
        }
    }
    register PCIEPHY_CTRL_286 @0x478 {
    bytes 4;
        field protocol0_ext_rx_eq_dfe_tap1_g4_31_0 {
            bits 32;
            reset 0x0;
            access rw;
        }
    }
    register PCIEPHY_CTRL_287 @0x47C {
    bytes 4;
        field protocol0_ext_rx_eq_dfe_tap1_g4_63_32 {
            bits 32;
            reset 0x0;
            access rw;
        }
    }
    register PCIEPHY_CTRL_288 @0x480 {
    bytes 4;
        field protocol0_ext_rx_eq_dfe_tap1_g4_95_64 {
            bits 32;
            reset 0x0;
            access rw;
        }
    }
    register PCIEPHY_CTRL_289 @0x484 {
    bytes 4;
        field protocol0_ext_rx_eq_dfe_tap1_g4_127_96 {
            bits 32;
            reset 0x0;
            access rw;
        }
    }
    register PCIEPHY_CTRL_290 @0x488 {
    bytes 4;
        field protocol0_ext_rx_eq_dfe_tap1_g5_31_0 {
            bits 32;
            reset 0x0;
            access rw;
        }
    }
    register PCIEPHY_CTRL_291 @0x48C {
    bytes 4;
        field protocol0_ext_rx_eq_dfe_tap1_g5_63_32 {
            bits 32;
            reset 0x0;
            access rw;
        }
    }
    register PCIEPHY_CTRL_292 @0x490 {
    bytes 4;
        field protocol0_ext_rx_eq_dfe_tap1_g5_95_64 {
            bits 32;
            reset 0x0;
            access rw;
        }
    }
    register PCIEPHY_CTRL_293 @0x494 {
    bytes 4;
        field protocol0_ext_rx_eq_dfe_tap1_g5_127_96 {
            bits 32;
            reset 0x0;
            access rw;
        }
    }
    register PCIEPHY_CTRL_294 @0x498 {
    bytes 4;
        field protocol0_ext_rx_eq_dfe_tap1_g1_143_128 {
            bits 16;
            reset 0x0;
            access rw;
        }
        field protocol0_ext_rx_eq_dfe_tap1_g2_143_128 @ 16 {
            bits 16;
            reset 0x0;
            access rw;
        }
    }
    register PCIEPHY_CTRL_295 @0x49C {
    bytes 4;
        field protocol0_ext_rx_eq_dfe_tap1_g3_143_128 {
            bits 16;
            reset 0x0;
            access rw;
        }
        field protocol0_ext_rx_eq_dfe_tap1_g4_143_128 @ 16 {
            bits 16;
            reset 0x0;
            access rw;
        }
    }
    register PCIEPHY_CTRL_296 @0x4A0 {
    bytes 4;
        field protocol0_ext_rx_eq_dfe_tap1_g5_143_128 {
            bits 16;
            reset 0x0;
            access rw;
        }
    }
    register PCIEPHY_CTRL_297 @0x4A4 {
    bytes 4;
        field protocol0_ext_rx_eq_dfe_tap2_g1 {
            bits 8;
            reset 0x0;
            access rw;
        }
        field protocol0_ext_rx_eq_dfe_tap2_g2 @ 8 {
            bits 8;
            reset 0x0;
            access rw;
        }
        field protocol0_ext_rx_eq_dfe_tap2_g3 @ 16 {
            bits 8;
            reset 0x0;
            access rw;
        }
        field protocol0_ext_rx_eq_dfe_tap2_g4 @ 24 {
            bits 8;
            reset 0x0;
            access rw;
        }
    }
    register PCIEPHY_CTRL_298 @0x4A8 {
    bytes 4;
        field protocol0_ext_rx_eq_dfe_tap2_g5 {
            bits 8;
            reset 0x0;
            access rw;
        }
        field protocol0_ext_rx_eq_vga_gain_g1 @ 8 {
            bits 4;
            reset 0x0;
            access rw;
        }
        field protocol0_ext_rx_eq_vga_gain_g2 @ 12 {
            bits 4;
            reset 0x0;
            access rw;
        }
        field protocol0_ext_rx_eq_vga_gain_g3 @ 16 {
            bits 4;
            reset 0x0;
            access rw;
        }
        field protocol0_ext_rx_eq_vga_gain_g4 @ 20 {
            bits 4;
            reset 0x0;
            access rw;
        }
        field protocol0_ext_rx_eq_vga_gain_g5 @ 24 {
            bits 4;
            reset 0x0;
            access rw;
        }
    }
    register PCIEPHY_CTRL_299 @0x4AC {
    bytes 4;
        field protocol0_ext_rx_los_pwr_up_cnt {
            bits 11;
            reset 0x0;
            access rw;
        }
    }
    register PCIEPHY_CTRL_300 @0x4B0 {
    bytes 4;
        field protocol0_ext_rx_misc_g1_31_0 {
            bits 32;
            reset 0x0;
            access rw;
        }
    }
    register PCIEPHY_CTRL_301 @0x4B4 {
    bytes 4;
        field protocol0_ext_rx_misc_g1_63_32 {
            bits 32;
            reset 0x0;
            access rw;
        }
    }
    register PCIEPHY_CTRL_302 @0x4B8 {
    bytes 4;
        field protocol0_ext_rx_misc_g1_127_64 {
            bits 32;
            reset 0x0;
            access rw;
        }
    }
    register PCIEPHY_CTRL_303 @0x4BC {
    bytes 4;
        field protocol0_ext_rx_misc_g1_159_128 {
            bits 32;
            reset 0x0;
            access rw;
        }
    }
    register PCIEPHY_CTRL_304 @0x4C0 {
    bytes 4;
        field protocol0_ext_rx_misc_g1_191_160 {
            bits 32;
            reset 0x0;
            access rw;
        }
    }
    register PCIEPHY_CTRL_305 @0x4C4 {
    bytes 4;
        field protocol0_ext_rx_misc_g1_223_192 {
            bits 32;
            reset 0x0;
            access rw;
        }
    }
    register PCIEPHY_CTRL_306 @0x4C8 {
    bytes 4;
        field protocol0_ext_rx_misc_g1_255_224 {
            bits 32;
            reset 0x0;
            access rw;
        }
    }
    register PCIEPHY_CTRL_307 @0x4CC {
    bytes 4;
        field protocol0_ext_rx_misc_g1_287_256 {
            bits 32;
            reset 0x0;
            access rw;
        }
    }
    register PCIEPHY_CTRL_308 @0x4D0 {
    bytes 4;
        field protocol0_ext_rx_misc_g1_319_288 {
            bits 32;
            reset 0x0;
            access rw;
        }
    }
    register PCIEPHY_CTRL_309 @0x4D4 {
    bytes 4;
        field protocol0_ext_rx_misc_g1_351_320 {
            bits 32;
            reset 0x0;
            access rw;
        }
    }
    register PCIEPHY_CTRL_310 @0x4D8 {
    bytes 4;
        field protocol0_ext_rx_misc_g1_383_352 {
            bits 32;
            reset 0x0;
            access rw;
        }
    }
    register PCIEPHY_CTRL_311 @0x4DC {
    bytes 4;
        field protocol0_ext_rx_misc_g2_31_0 {
            bits 32;
            reset 0x0;
            access rw;
        }
    }
    register PCIEPHY_CTRL_312 @0x4E0 {
    bytes 4;
        field protocol0_ext_rx_misc_g2_63_32 {
            bits 32;
            reset 0x0;
            access rw;
        }
    }
    register PCIEPHY_CTRL_313 @0x4E4 {
    bytes 4;
        field protocol0_ext_rx_misc_g2_127_64 {
            bits 32;
            reset 0x0;
            access rw;
        }
    }
    register PCIEPHY_CTRL_314 @0x4E8 {
    bytes 4;
        field protocol0_ext_rx_misc_g2_159_128 {
            bits 32;
            reset 0x0;
            access rw;
        }
    }
    register PCIEPHY_CTRL_315 @0x4EC {
    bytes 4;
        field protocol0_ext_rx_misc_g2_191_160 {
            bits 32;
            reset 0x0;
            access rw;
        }
    }
    register PCIEPHY_CTRL_316 @0x4F0 {
    bytes 4;
        field protocol0_ext_rx_misc_g2_223_192 {
            bits 32;
            reset 0x0;
            access rw;
        }
    }
    register PCIEPHY_CTRL_317 @0x4F4 {
    bytes 4;
        field protocol0_ext_rx_misc_g2_255_224 {
            bits 32;
            reset 0x0;
            access rw;
        }
    }
    register PCIEPHY_CTRL_318 @0x4F8 {
    bytes 4;
        field protocol0_ext_rx_misc_g2_287_256 {
            bits 32;
            reset 0x0;
            access rw;
        }
    }
    register PCIEPHY_CTRL_319 @0x4FC {
    bytes 4;
        field protocol0_ext_rx_misc_g2_319_288 {
            bits 32;
            reset 0x0;
            access rw;
        }
    }
    register PCIEPHY_CTRL_320 @0x500 {
    bytes 4;
        field protocol0_ext_rx_misc_g2_351_320 {
            bits 32;
            reset 0x0;
            access rw;
        }
    }
    register PCIEPHY_CTRL_321 @0x504 {
    bytes 4;
        field protocol0_ext_rx_misc_g2_383_352 {
            bits 32;
            reset 0x0;
            access rw;
        }
    }
    register PCIEPHY_CTRL_322 @0x508 {
    bytes 4;
        field protocol0_ext_rx_misc_g3_31_0 {
            bits 32;
            reset 0x0;
            access rw;
        }
    }
    register PCIEPHY_CTRL_323 @0x50C {
    bytes 4;
        field protocol0_ext_rx_misc_g3_63_32 {
            bits 32;
            reset 0x0;
            access rw;
        }
    }
    register PCIEPHY_CTRL_324 @0x510 {
    bytes 4;
        field protocol0_ext_rx_misc_g3_127_64 {
            bits 32;
            reset 0x0;
            access rw;
        }
    }
    register PCIEPHY_CTRL_325 @0x514 {
    bytes 4;
        field protocol0_ext_rx_misc_g3_159_128 {
            bits 32;
            reset 0x0;
            access rw;
        }
    }
    register PCIEPHY_CTRL_326 @0x518 {
    bytes 4;
        field protocol0_ext_rx_misc_g3_191_160 {
            bits 32;
            reset 0x0;
            access rw;
        }
    }
    register PCIEPHY_CTRL_327 @0x51C {
    bytes 4;
        field protocol0_ext_rx_misc_g3_223_192 {
            bits 32;
            reset 0x0;
            access rw;
        }
    }
    register PCIEPHY_CTRL_328 @0x520 {
    bytes 4;
        field protocol0_ext_rx_misc_g3_255_224 {
            bits 32;
            reset 0x0;
            access rw;
        }
    }
    register PCIEPHY_CTRL_329 @0x524 {
    bytes 4;
        field protocol0_ext_rx_misc_g3_287_256 {
            bits 32;
            reset 0x0;
            access rw;
        }
    }
    register PCIEPHY_CTRL_330 @0x528 {
    bytes 4;
        field protocol0_ext_rx_misc_g3_319_288 {
            bits 32;
            reset 0x0;
            access rw;
        }
    }
    register PCIEPHY_CTRL_331 @0x52C {
    bytes 4;
        field protocol0_ext_rx_misc_g3_351_320 {
            bits 32;
            reset 0x0;
            access rw;
        }
    }
    register PCIEPHY_CTRL_332 @0x530 {
    bytes 4;
        field protocol0_ext_rx_misc_g3_383_352 {
            bits 32;
            reset 0x0;
            access rw;
        }
    }
    register PCIEPHY_CTRL_333 @0x534 {
    bytes 4;
        field protocol0_ext_rx_misc_g4_31_0 {
            bits 32;
            reset 0x0;
            access rw;
        }
    }
    register PCIEPHY_CTRL_334 @0x538 {
    bytes 4;
        field protocol0_ext_rx_misc_g4_63_32 {
            bits 32;
            reset 0x0;
            access rw;
        }
    }
    register PCIEPHY_CTRL_335 @0x53C {
    bytes 4;
        field protocol0_ext_rx_misc_g4_127_64 {
            bits 32;
            reset 0x0;
            access rw;
        }
    }
    register PCIEPHY_CTRL_336 @0x540 {
    bytes 4;
        field protocol0_ext_rx_misc_g4_159_128 {
            bits 32;
            reset 0x0;
            access rw;
        }
    }
    register PCIEPHY_CTRL_337 @0x544 {
    bytes 4;
        field protocol0_ext_rx_misc_g4_191_160 {
            bits 32;
            reset 0x0;
            access rw;
        }
    }
    register PCIEPHY_CTRL_338 @0x548 {
    bytes 4;
        field protocol0_ext_rx_misc_g4_223_192 {
            bits 32;
            reset 0x0;
            access rw;
        }
    }
    register PCIEPHY_CTRL_339 @0x54C {
    bytes 4;
        field protocol0_ext_rx_misc_g4_255_224 {
            bits 32;
            reset 0x0;
            access rw;
        }
    }
    register PCIEPHY_CTRL_340 @0x550 {
    bytes 4;
        field protocol0_ext_rx_misc_g4_287_256 {
            bits 32;
            reset 0x0;
            access rw;
        }
    }
    register PCIEPHY_CTRL_341 @0x554 {
    bytes 4;
        field protocol0_ext_rx_misc_g4_319_288 {
            bits 32;
            reset 0x0;
            access rw;
        }
    }
    register PCIEPHY_CTRL_342 @0x558 {
    bytes 4;
        field protocol0_ext_rx_misc_g4_351_320 {
            bits 32;
            reset 0x0;
            access rw;
        }
    }
    register PCIEPHY_CTRL_343 @0x55C {
    bytes 4;
        field protocol0_ext_rx_misc_g4_383_352 {
            bits 32;
            reset 0x0;
            access rw;
        }
    }
    register PCIEPHY_CTRL_344 @0x560 {
    bytes 4;
        field protocol0_ext_rx_misc_g5_31_0 {
            bits 32;
            reset 0x0;
            access rw;
        }
    }
    register PCIEPHY_CTRL_345 @0x564 {
    bytes 4;
        field protocol0_ext_rx_misc_g5_63_32 {
            bits 32;
            reset 0x0;
            access rw;
        }
    }
    register PCIEPHY_CTRL_346 @0x568 {
    bytes 4;
        field protocol0_ext_rx_misc_g5_127_64 {
            bits 32;
            reset 0x0;
            access rw;
        }
    }
    register PCIEPHY_CTRL_347 @0x56C {
    bytes 4;
        field protocol0_ext_rx_misc_g5_159_128 {
            bits 32;
            reset 0x0;
            access rw;
        }
    }
    register PCIEPHY_CTRL_348 @0x570 {
    bytes 4;
        field protocol0_ext_rx_misc_g5_191_160 {
            bits 32;
            reset 0x0;
            access rw;
        }
    }
    register PCIEPHY_CTRL_349 @0x574 {
    bytes 4;
        field protocol0_ext_rx_misc_g5_223_192 {
            bits 32;
            reset 0x0;
            access rw;
        }
    }
    register PCIEPHY_CTRL_350 @0x578 {
    bytes 4;
        field protocol0_ext_rx_misc_g5_255_224 {
            bits 32;
            reset 0x0;
            access rw;
        }
    }
    register PCIEPHY_CTRL_351 @0x57C {
    bytes 4;
        field protocol0_ext_rx_misc_g5_287_256 {
            bits 32;
            reset 0x0;
            access rw;
        }
    }
    register PCIEPHY_CTRL_352 @0x580 {
    bytes 4;
        field protocol0_ext_rx_misc_g5_319_288 {
            bits 32;
            reset 0x0;
            access rw;
        }
    }
    register PCIEPHY_CTRL_353 @0x584 {
    bytes 4;
        field protocol0_ext_rx_misc_g5_351_320 {
            bits 32;
            reset 0x0;
            access rw;
        }
    }
    register PCIEPHY_CTRL_354 @0x588 {
    bytes 4;
        field protocol0_ext_rx_misc_g5_383_352 {
            bits 32;
            reset 0x0;
            access rw;
        }
    }
    register PCIEPHY_CTRL_355 @0x58C {
    bytes 4;
        field protocol0_ext_rx_ref_ld_val_g1 {
            bits 7;
            reset 0x0;
            access rw;
        }
        field protocol0_ext_rx_ref_ld_val_g2 @ 7 {
            bits 7;
            reset 0x0;
            access rw;
        }
        field protocol0_ext_rx_ref_ld_val_g3 @ 14 {
            bits 7;
            reset 0x0;
            access rw;
        }
        field protocol0_ext_rx_ref_ld_val_g4 @ 21 {
            bits 7;
            reset 0x0;
            access rw;
        }
    }
    register PCIEPHY_CTRL_356 @0x590 {
    bytes 4;
        field protocol0_ext_rx_ref_ld_val_g5 {
            bits 7;
            reset 0x0;
            access rw;
        }
        field protocol0_ext_rx_sigdet_lf_threshold_g1 @ 7 {
            bits 2;
            reset 0x0;
            access rw;
        }
        field protocol0_ext_rx_sigdet_lf_threshold_g2 @ 9 {
            bits 2;
            reset 0x0;
            access rw;
        }
        field protocol0_ext_rx_sigdet_lf_threshold_g3 @ 11 {
            bits 2;
            reset 0x0;
            access rw;
        }
        field protocol0_ext_rx_sigdet_lf_threshold_g4 @ 13 {
            bits 2;
            reset 0x0;
            access rw;
        }
        field protocol0_ext_rx_sigdet_lf_threshold_g5 @ 15 {
            bits 2;
            reset 0x0;
            access rw;
        }
        field protocol0_ext_rx_sigdet_lfps_filter_en_g1 @ 17 {
            bits 1;
            reset 0x0;
            access rw;
        }
        field protocol0_ext_rx_sigdet_lfps_filter_en_g2 @ 18 {
            bits 1;
            reset 0x0;
            access rw;
        }
        field protocol0_ext_rx_sigdet_lfps_filter_en_g3 @ 19 {
            bits 1;
            reset 0x0;
            access rw;
        }
        field protocol0_ext_rx_sigdet_lfps_filter_en_g4 @ 20 {
            bits 1;
            reset 0x0;
            access rw;
        }
        field protocol0_ext_rx_sigdet_lfps_filter_en_g5 @ 21 {
            bits 1;
            reset 0x0;
            access rw;
        }
        field protocol0_ext_rx_term_ctrl_g1 @ 22 {
            bits 4;
            reset 0x0;
            access rw;
        }
        field protocol0_ext_rx_term_ctrl_g2 @ 26 {
            bits 4;
            reset 0x0;
            access rw;
        }
    }
    register PCIEPHY_CTRL_357 @0x594 {
    bytes 4;
        field protocol0_ext_rx_term_ctrl_g3 {
            bits 4;
            reset 0x0;
            access rw;
        }
        field protocol0_ext_rx_term_ctrl_g4 @ 4 {
            bits 4;
            reset 0x0;
            access rw;
        }
        field protocol0_ext_rx_term_ctrl_g5 @ 8 {
            bits 4;
            reset 0x0;
            access rw;
        }
    }
    register PCIEPHY_CTRL_358 @0x598 {
    bytes 4;
        field protocol0_ext_rx_vco_ld_val_g1 {
            bits 13;
            reset 0x0;
            access rw;
        }
        field protocol0_ext_rx_vco_ld_val_g2 @ 13 {
            bits 13;
            reset 0x0;
            access rw;
        }
    }
    register PCIEPHY_CTRL_359 @0x59C {
    bytes 4;
        field protocol0_ext_rx_vco_ld_val_g3 {
            bits 13;
            reset 0x0;
            access rw;
        }
        field protocol0_ext_rx_vco_ld_val_g4 @ 13 {
            bits 13;
            reset 0x0;
            access rw;
        }
    }
    register PCIEPHY_CTRL_360 @0x5A0 {
    bytes 4;
        field protocol0_ext_rx_vco_ld_val_g5 {
            bits 13;
            reset 0x0;
            access rw;
        }
        field protocol0_ext_rx_vref_ctrl @ 13 {
            bits 5;
            reset 0x0;
            access rw;
        }
        field protocol0_ext_tx_dcc_ctrl_cm_range_g1 @ 18 {
            bits 4;
            reset 0x0;
            access rw;
        }
        field protocol0_ext_tx_dcc_ctrl_cm_range_g2 @ 22 {
            bits 4;
            reset 0x0;
            access rw;
        }
        field protocol0_ext_tx_dcc_ctrl_cm_range_g3 @ 26 {
            bits 4;
            reset 0x0;
            access rw;
        }
    }
    register PCIEPHY_CTRL_361 @0x5A4 {
    bytes 4;
        field protocol0_ext_tx_dcc_ctrl_cm_range_g4 {
            bits 4;
            reset 0x0;
            access rw;
        }
        field protocol0_ext_tx_dcc_ctrl_cm_range_g5 @ 4 {
            bits 4;
            reset 0x0;
            access rw;
        }
        field protocol0_ext_tx_dcc_ctrl_diff_range_g1 @ 8 {
            bits 4;
            reset 0x0;
            access rw;
        }
        field protocol0_ext_tx_dcc_ctrl_diff_range_g2 @ 12 {
            bits 4;
            reset 0x0;
            access rw;
        }
        field protocol0_ext_tx_dcc_ctrl_diff_range_g3 @ 16 {
            bits 4;
            reset 0x0;
            access rw;
        }
        field protocol0_ext_tx_dcc_ctrl_diff_range_g4 @ 20 {
            bits 4;
            reset 0x0;
            access rw;
        }
        field protocol0_ext_tx_dcc_ctrl_diff_range_g5 @ 24 {
            bits 4;
            reset 0x0;
            access rw;
        }
    }
    register PCIEPHY_CTRL_362 @0x5A8 {
    bytes 4;
        field protocol0_ext_tx_eq_main_g1_31_0 {
            bits 32;
            reset 0x0;
            access rw;
        }
    }
    register PCIEPHY_CTRL_363 @0x5AC {
    bytes 4;
        field protocol0_ext_tx_eq_main_g1_63_32 {
            bits 32;
            reset 0x0;
            access rw;
        }
    }
    register PCIEPHY_CTRL_364 @0x5B0 {
    bytes 4;
        field protocol0_ext_tx_eq_main_g1_95_64 {
            bits 32;
            reset 0x0;
            access rw;
        }
    }
    register PCIEPHY_CTRL_365 @0x5B4 {
    bytes 4;
        field protocol0_ext_tx_eq_main_g2_31_0 {
            bits 32;
            reset 0x0;
            access rw;
        }
    }
    register PCIEPHY_CTRL_366 @0x5B8 {
    bytes 4;
        field protocol0_ext_tx_eq_main_g2_63_32 {
            bits 32;
            reset 0x0;
            access rw;
        }
    }
    register PCIEPHY_CTRL_367 @0x5BC {
    bytes 4;
        field protocol0_ext_tx_eq_main_g2_95_64 {
            bits 32;
            reset 0x0;
            access rw;
        }
    }
    register PCIEPHY_CTRL_368 @0x5C0 {
    bytes 4;
        field protocol0_ext_tx_eq_main_g3_31_0 {
            bits 32;
            reset 0x0;
            access rw;
        }
    }
    register PCIEPHY_CTRL_369 @0x5C4 {
    bytes 4;
        field protocol0_ext_tx_eq_main_g3_63_32 {
            bits 32;
            reset 0x0;
            access rw;
        }
    }
    register PCIEPHY_CTRL_370 @0x5C8 {
    bytes 4;
        field protocol0_ext_tx_eq_main_g3_95_64 {
            bits 32;
            reset 0x0;
            access rw;
        }
    }
    register PCIEPHY_CTRL_371 @0x5CC {
    bytes 4;
        field protocol0_ext_tx_eq_main_g4_31_0 {
            bits 32;
            reset 0x0;
            access rw;
        }
    }
    register PCIEPHY_CTRL_372 @0x5D0 {
    bytes 4;
        field protocol0_ext_tx_eq_main_g4_63_32 {
            bits 32;
            reset 0x0;
            access rw;
        }
    }
    register PCIEPHY_CTRL_373 @0x5D4 {
    bytes 4;
        field protocol0_ext_tx_eq_main_g4_95_64 {
            bits 32;
            reset 0x0;
            access rw;
        }
    }
    register PCIEPHY_CTRL_374 @0x5D8 {
    bytes 4;
        field protocol0_ext_tx_eq_main_g5_31_0 {
            bits 32;
            reset 0x0;
            access rw;
        }
    }
    register PCIEPHY_CTRL_375 @0x5DC {
    bytes 4;
        field protocol0_ext_tx_eq_main_g5_63_32 {
            bits 32;
            reset 0x0;
            access rw;
        }
    }
    register PCIEPHY_CTRL_376 @0x5E0 {
    bytes 4;
        field protocol0_ext_tx_eq_main_g5_95_64 {
            bits 32;
            reset 0x0;
            access rw;
        }
    }
    register PCIEPHY_CTRL_377 @0x5E4 {
    bytes 4;
        field protocol0_ext_tx_eq_ovrd_g1 {
            bits 16;
            reset 0x0;
            access rw;
        }
        field protocol0_ext_tx_eq_ovrd_g2 @ 16 {
            bits 16;
            reset 0x0;
            access rw;
        }
    }
    register PCIEPHY_CTRL_378 @0x5E8 {
    bytes 4;
        field protocol0_ext_tx_eq_ovrd_g3 {
            bits 16;
            reset 0x0;
            access rw;
        }
        field protocol0_ext_tx_eq_ovrd_g4 @ 16 {
            bits 16;
            reset 0x0;
            access rw;
        }
    }
    register PCIEPHY_CTRL_379 @0x5EC {
    bytes 4;
        field protocol0_ext_tx_eq_ovrd_g5 {
            bits 16;
            reset 0x0;
            access rw;
        }
    }
    register PCIEPHY_CTRL_380 @0x5F0 {
    bytes 4;
        field protocol0_ext_tx_eq_post_g1_31_0 {
            bits 32;
            reset 0x0;
            access rw;
        }
    }
    register PCIEPHY_CTRL_381 @0x5F4 {
    bytes 4;
        field protocol0_ext_tx_eq_post_g1_63_32 {
            bits 32;
            reset 0x0;
            access rw;
        }
    }
    register PCIEPHY_CTRL_382 @0x5F8 {
    bytes 4;
        field protocol0_ext_tx_eq_post_g2_31_0 {
            bits 32;
            reset 0x0;
            access rw;
        }
    }
    register PCIEPHY_CTRL_383 @0x5FC {
    bytes 4;
        field protocol0_ext_tx_eq_post_g2_63_32 {
            bits 32;
            reset 0x0;
            access rw;
        }
    }
    register PCIEPHY_CTRL_384 @0x600 {
    bytes 4;
        field protocol0_ext_tx_eq_post_g3_31_0 {
            bits 32;
            reset 0x0;
            access rw;
        }
    }
    register PCIEPHY_CTRL_385 @0x604 {
    bytes 4;
        field protocol0_ext_tx_eq_post_g3_63_32 {
            bits 32;
            reset 0x0;
            access rw;
        }
    }
    register PCIEPHY_CTRL_386 @0x608 {
    bytes 4;
        field protocol0_ext_tx_eq_post_g4_31_0 {
            bits 32;
            reset 0x0;
            access rw;
        }
    }
    register PCIEPHY_CTRL_387 @0x60C {
    bytes 4;
        field protocol0_ext_tx_eq_post_g4_63_32 {
            bits 32;
            reset 0x0;
            access rw;
        }
    }
    register PCIEPHY_CTRL_388 @0x610 {
    bytes 4;
        field protocol0_ext_tx_eq_post_g5_31_0 {
            bits 32;
            reset 0x0;
            access rw;
        }
    }
    register PCIEPHY_CTRL_389 @0x614 {
    bytes 4;
        field protocol0_ext_tx_eq_post_g5_63_32 {
            bits 32;
            reset 0x0;
            access rw;
        }
    }
    register PCIEPHY_CTRL_390 @0x618 {
    bytes 4;
        field protocol0_ext_tx_eq_post_g1_79_64 {
            bits 16;
            reset 0x0;
            access rw;
        }
        field protocol0_ext_tx_eq_post_g2_79_64 @ 16 {
            bits 16;
            reset 0x0;
            access rw;
        }
    }
    register PCIEPHY_CTRL_391 @0x61C {
    bytes 4;
        field protocol0_ext_tx_eq_post_g3_79_64 {
            bits 16;
            reset 0x0;
            access rw;
        }
        field protocol0_ext_tx_eq_post_g4_79_64 @ 16 {
            bits 16;
            reset 0x0;
            access rw;
        }
    }
    register PCIEPHY_CTRL_392 @0x620 {
    bytes 4;
        field protocol0_ext_tx_eq_post_g5_79_64 {
            bits 16;
            reset 0x0;
            access rw;
        }
    }
    register PCIEPHY_CTRL_393 @0x624 {
    bytes 4;
        field protocol0_ext_tx_eq_pre_g1_31_0 {
            bits 32;
            reset 0x0;
            access rw;
        }
    }
    register PCIEPHY_CTRL_394 @0x628 {
    bytes 4;
        field protocol0_ext_tx_eq_pre_g1_63_32 {
            bits 32;
            reset 0x0;
            access rw;
        }
    }
    register PCIEPHY_CTRL_395 @0x62C {
    bytes 4;
        field protocol0_ext_tx_eq_pre_g2_31_0 {
            bits 32;
            reset 0x0;
            access rw;
        }
    }
    register PCIEPHY_CTRL_396 @0x630 {
    bytes 4;
        field protocol0_ext_tx_eq_pre_g2_63_32 {
            bits 32;
            reset 0x0;
            access rw;
        }
    }
    register PCIEPHY_CTRL_397 @0x634 {
    bytes 4;
        field protocol0_ext_tx_eq_pre_g3_31_0 {
            bits 32;
            reset 0x0;
            access rw;
        }
    }
    register PCIEPHY_CTRL_398 @0x638 {
    bytes 4;
        field protocol0_ext_tx_eq_pre_g3_63_32 {
            bits 32;
            reset 0x0;
            access rw;
        }
    }
    register PCIEPHY_CTRL_399 @0x63C {
    bytes 4;
        field protocol0_ext_tx_eq_pre_g4_31_0 {
            bits 32;
            reset 0x0;
            access rw;
        }
    }
    register PCIEPHY_CTRL_400 @0x640 {
    bytes 4;
        field protocol0_ext_tx_eq_pre_g4_63_32 {
            bits 32;
            reset 0x0;
            access rw;
        }
    }
    register PCIEPHY_CTRL_401 @0x644 {
    bytes 4;
        field protocol0_ext_tx_eq_pre_g5_31_0 {
            bits 32;
            reset 0x0;
            access rw;
        }
    }
    register PCIEPHY_CTRL_402 @0x648 {
    bytes 4;
        field protocol0_ext_tx_eq_pre_g5_63_32 {
            bits 32;
            reset 0x0;
            access rw;
        }
    }
    register PCIEPHY_CTRL_403 @0x64C {
    bytes 4;
        field protocol0_ext_tx_eq_pre_g1_79_64 {
            bits 16;
            reset 0x0;
            access rw;
        }
        field protocol0_ext_tx_eq_pre_g2_79_64 @ 16 {
            bits 16;
            reset 0x0;
            access rw;
        }
    }
    register PCIEPHY_CTRL_404 @0x650 {
    bytes 4;
        field protocol0_ext_tx_eq_pre_g3_79_64 {
            bits 16;
            reset 0x0;
            access rw;
        }
        field protocol0_ext_tx_eq_pre_g4_79_64 @ 16 {
            bits 16;
            reset 0x0;
            access rw;
        }
    }
    register PCIEPHY_CTRL_405 @0x654 {
    bytes 4;
        field protocol0_ext_tx_eq_pre_g5_79_64 {
            bits 16;
            reset 0x0;
            access rw;
        }
        field protocol0_ext_tx_fastedge_en_g1 @ 16 {
            bits 1;
            reset 0x0;
            access rw;
        }
        field protocol0_ext_tx_fastedge_en_g2 @ 17 {
            bits 1;
            reset 0x0;
            access rw;
        }
        field protocol0_ext_tx_fastedge_en_g3 @ 18 {
            bits 1;
            reset 0x0;
            access rw;
        }
        field protocol0_ext_tx_fastedge_en_g4 @ 19 {
            bits 1;
            reset 0x0;
            access rw;
        }
        field protocol0_ext_tx_fastedge_en_g5 @ 20 {
            bits 1;
            reset 0x0;
            access rw;
        }
    }
    register PCIEPHY_CTRL_406 @0x658 {
    bytes 4;
        field protocol0_ext_tx_misc_g1_31_0 {
            bits 32;
            reset 0x0;
            access rw;
        }
    }
    register PCIEPHY_CTRL_407 @0x65C {
    bytes 4;
        field protocol0_ext_tx_misc_g1_63_32 {
            bits 32;
            reset 0x0;
            access rw;
        }
    }
    register PCIEPHY_CTRL_408 @0x660 {
    bytes 4;
        field protocol0_ext_tx_misc_g1_95_64 {
            bits 32;
            reset 0x0;
            access rw;
        }
    }
    register PCIEPHY_CTRL_409 @0x664 {
    bytes 4;
        field protocol0_ext_tx_misc_g1_127_96 {
            bits 32;
            reset 0x0;
            access rw;
        }
    }
    register PCIEPHY_CTRL_410 @0x668 {
    bytes 4;
        field protocol0_ext_tx_misc_g1_159_128 {
            bits 32;
            reset 0x0;
            access rw;
        }
    }
    register PCIEPHY_CTRL_411 @0x66C {
    bytes 4;
        field protocol0_ext_tx_misc_g1_191_160 {
            bits 32;
            reset 0x0;
            access rw;
        }
    }
    register PCIEPHY_CTRL_412 @0x670 {
    bytes 4;
        field protocol0_ext_tx_misc_g1_223_192 {
            bits 32;
            reset 0x0;
            access rw;
        }
    }
    register PCIEPHY_CTRL_413 @0x674 {
    bytes 4;
        field protocol0_ext_tx_misc_g1_255_223 {
            bits 32;
            reset 0x0;
            access rw;
        }
    }
    register PCIEPHY_CTRL_414 @0x678 {
    bytes 4;
        field protocol0_ext_tx_misc_g1_287_256 {
            bits 32;
            reset 0x0;
            access rw;
        }
    }
    register PCIEPHY_CTRL_415 @0x67C {
    bytes 4;
        field protocol0_ext_tx_misc_g1_319_288 {
            bits 32;
            reset 0x0;
            access rw;
        }
    }
    register PCIEPHY_CTRL_416 @0x680 {
    bytes 4;
        field protocol0_ext_tx_misc_g1_351_320 {
            bits 32;
            reset 0x0;
            access rw;
        }
    }
    register PCIEPHY_CTRL_417 @0x684 {
    bytes 4;
        field protocol0_ext_tx_misc_g1_383_352 {
            bits 32;
            reset 0x0;
            access rw;
        }
    }
    register PCIEPHY_CTRL_418 @0x688 {
    bytes 4;
        field protocol0_ext_tx_misc_g2_31_0 {
            bits 32;
            reset 0x0;
            access rw;
        }
    }
    register PCIEPHY_CTRL_419 @0x68C {
    bytes 4;
        field protocol0_ext_tx_misc_g2_63_32 {
            bits 32;
            reset 0x0;
            access rw;
        }
    }
    register PCIEPHY_CTRL_420 @0x690 {
    bytes 4;
        field protocol0_ext_tx_misc_g2_95_64 {
            bits 32;
            reset 0x0;
            access rw;
        }
    }
    register PCIEPHY_CTRL_421 @0x694 {
    bytes 4;
        field protocol0_ext_tx_misc_g2_127_96 {
            bits 32;
            reset 0x0;
            access rw;
        }
    }
    register PCIEPHY_CTRL_422 @0x698 {
    bytes 4;
        field protocol0_ext_tx_misc_g2_159_128 {
            bits 32;
            reset 0x0;
            access rw;
        }
    }
    register PCIEPHY_CTRL_423 @0x69C {
    bytes 4;
        field protocol0_ext_tx_misc_g2_191_160 {
            bits 32;
            reset 0x0;
            access rw;
        }
    }
    register PCIEPHY_CTRL_424 @0x6A0 {
    bytes 4;
        field protocol0_ext_tx_misc_g2_223_192 {
            bits 32;
            reset 0x0;
            access rw;
        }
    }
    register PCIEPHY_CTRL_425 @0x6A4 {
    bytes 4;
        field protocol0_ext_tx_misc_g2_255_223 {
            bits 32;
            reset 0x0;
            access rw;
        }
    }
    register PCIEPHY_CTRL_426 @0x6A8 {
    bytes 4;
        field protocol0_ext_tx_misc_g2_287_256 {
            bits 32;
            reset 0x0;
            access rw;
        }
    }
    register PCIEPHY_CTRL_427 @0x6AC {
    bytes 4;
        field protocol0_ext_tx_misc_g2_319_288 {
            bits 32;
            reset 0x0;
            access rw;
        }
    }
    register PCIEPHY_CTRL_428 @0x6B0 {
    bytes 4;
        field protocol0_ext_tx_misc_g2_351_320 {
            bits 32;
            reset 0x0;
            access rw;
        }
    }
    register PCIEPHY_CTRL_429 @0x6B4 {
    bytes 4;
        field protocol0_ext_tx_misc_g2_383_352 {
            bits 32;
            reset 0x0;
            access rw;
        }
    }
    register PCIEPHY_CTRL_430 @0x6B8 {
    bytes 4;
        field protocol0_ext_tx_misc_g3_31_0 {
            bits 32;
            reset 0x0;
            access rw;
        }
    }
    register PCIEPHY_CTRL_431 @0x6BC {
    bytes 4;
        field protocol0_ext_tx_misc_g3_63_32 {
            bits 32;
            reset 0x0;
            access rw;
        }
    }
    register PCIEPHY_CTRL_432 @0x6C0 {
    bytes 4;
        field protocol0_ext_tx_misc_g3_95_64 {
            bits 32;
            reset 0x0;
            access rw;
        }
    }
    register PCIEPHY_CTRL_433 @0x6C4 {
    bytes 4;
        field protocol0_ext_tx_misc_g3_127_96 {
            bits 32;
            reset 0x0;
            access rw;
        }
    }
    register PCIEPHY_CTRL_434 @0x6C8 {
    bytes 4;
        field protocol0_ext_tx_misc_g3_159_128 {
            bits 32;
            reset 0x0;
            access rw;
        }
    }
    register PCIEPHY_CTRL_435 @0x6CC {
    bytes 4;
        field protocol0_ext_tx_misc_g3_191_160 {
            bits 32;
            reset 0x0;
            access rw;
        }
    }
    register PCIEPHY_CTRL_436 @0x6D0 {
    bytes 4;
        field protocol0_ext_tx_misc_g3_223_192 {
            bits 32;
            reset 0x0;
            access rw;
        }
    }
    register PCIEPHY_CTRL_437 @0x6D4 {
    bytes 4;
        field protocol0_ext_tx_misc_g3_255_223 {
            bits 32;
            reset 0x0;
            access rw;
        }
    }
    register PCIEPHY_CTRL_438 @0x6D8 {
    bytes 4;
        field protocol0_ext_tx_misc_g3_287_256 {
            bits 32;
            reset 0x0;
            access rw;
        }
    }
    register PCIEPHY_CTRL_439 @0x6DC {
    bytes 4;
        field protocol0_ext_tx_misc_g3_319_288 {
            bits 32;
            reset 0x0;
            access rw;
        }
    }
    register PCIEPHY_CTRL_440 @0x6E0 {
    bytes 4;
        field protocol0_ext_tx_misc_g3_351_320 {
            bits 32;
            reset 0x0;
            access rw;
        }
    }
    register PCIEPHY_CTRL_441 @0x6E4 {
    bytes 4;
        field protocol0_ext_tx_misc_g3_383_352 {
            bits 32;
            reset 0x0;
            access rw;
        }
    }
    register PCIEPHY_CTRL_442 @0x6E8 {
    bytes 4;
        field protocol0_ext_tx_misc_g4_31_0 {
            bits 32;
            reset 0x0;
            access rw;
        }
    }
    register PCIEPHY_CTRL_443 @0x6EC {
    bytes 4;
        field protocol0_ext_tx_misc_g4_63_32 {
            bits 32;
            reset 0x0;
            access rw;
        }
    }
    register PCIEPHY_CTRL_444 @0x6F0 {
    bytes 4;
        field protocol0_ext_tx_misc_g4_95_64 {
            bits 32;
            reset 0x0;
            access rw;
        }
    }
    register PCIEPHY_CTRL_445 @0x6F4 {
    bytes 4;
        field protocol0_ext_tx_misc_g4_127_96 {
            bits 32;
            reset 0x0;
            access rw;
        }
    }
    register PCIEPHY_CTRL_446 @0x6F8 {
    bytes 4;
        field protocol0_ext_tx_misc_g4_159_128 {
            bits 32;
            reset 0x0;
            access rw;
        }
    }
    register PCIEPHY_CTRL_447 @0x6FC {
    bytes 4;
        field protocol0_ext_tx_misc_g4_191_160 {
            bits 32;
            reset 0x0;
            access rw;
        }
    }
    register PCIEPHY_CTRL_448 @0x700 {
    bytes 4;
        field protocol0_ext_tx_misc_g4_223_192 {
            bits 32;
            reset 0x0;
            access rw;
        }
    }
    register PCIEPHY_CTRL_449 @0x704 {
    bytes 4;
        field protocol0_ext_tx_misc_g4_255_223 {
            bits 32;
            reset 0x0;
            access rw;
        }
    }
    register PCIEPHY_CTRL_450 @0x708 {
    bytes 4;
        field protocol0_ext_tx_misc_g4_287_256 {
            bits 32;
            reset 0x0;
            access rw;
        }
    }
    register PCIEPHY_CTRL_451 @0x70C {
    bytes 4;
        field protocol0_ext_tx_misc_g4_319_288 {
            bits 32;
            reset 0x0;
            access rw;
        }
    }
    register PCIEPHY_CTRL_452 @0x710 {
    bytes 4;
        field protocol0_ext_tx_misc_g4_351_320 {
            bits 32;
            reset 0x0;
            access rw;
        }
    }
    register PCIEPHY_CTRL_453 @0x714 {
    bytes 4;
        field protocol0_ext_tx_misc_g4_383_352 {
            bits 32;
            reset 0x0;
            access rw;
        }
    }
    register PCIEPHY_CTRL_454 @0x718 {
    bytes 4;
        field protocol0_ext_tx_misc_g5_31_0 {
            bits 32;
            reset 0x0;
            access rw;
        }
    }
    register PCIEPHY_CTRL_455 @0x71C {
    bytes 4;
        field protocol0_ext_tx_misc_g5_63_32 {
            bits 32;
            reset 0x0;
            access rw;
        }
    }
    register PCIEPHY_CTRL_456 @0x720 {
    bytes 4;
        field protocol0_ext_tx_misc_g5_95_64 {
            bits 32;
            reset 0x0;
            access rw;
        }
    }
    register PCIEPHY_CTRL_457 @0x724 {
    bytes 4;
        field protocol0_ext_tx_misc_g5_127_96 {
            bits 32;
            reset 0x0;
            access rw;
        }
    }
    register PCIEPHY_CTRL_458 @0x728 {
    bytes 4;
        field protocol0_ext_tx_misc_g5_159_128 {
            bits 32;
            reset 0x0;
            access rw;
        }
    }
    register PCIEPHY_CTRL_459 @0x72C {
    bytes 4;
        field protocol0_ext_tx_misc_g5_191_160 {
            bits 32;
            reset 0x0;
            access rw;
        }
    }
    register PCIEPHY_CTRL_460 @0x730 {
    bytes 4;
        field protocol0_ext_tx_misc_g5_223_192 {
            bits 32;
            reset 0x0;
            access rw;
        }
    }
    register PCIEPHY_CTRL_461 @0x734 {
    bytes 4;
        field protocol0_ext_tx_misc_g5_255_223 {
            bits 32;
            reset 0x0;
            access rw;
        }
    }
    register PCIEPHY_CTRL_462 @0x738 {
    bytes 4;
        field protocol0_ext_tx_misc_g5_287_256 {
            bits 32;
            reset 0x0;
            access rw;
        }
    }
    register PCIEPHY_CTRL_463 @0x73C {
    bytes 4;
        field protocol0_ext_tx_misc_g5_319_288 {
            bits 32;
            reset 0x0;
            access rw;
        }
    }
    register PCIEPHY_CTRL_464 @0x740 {
    bytes 4;
        field protocol0_ext_tx_misc_g5_351_320 {
            bits 32;
            reset 0x0;
            access rw;
        }
    }
    register PCIEPHY_CTRL_465 @0x744 {
    bytes 4;
        field protocol0_ext_tx_misc_g5_383_352 {
            bits 32;
            reset 0x0;
            access rw;
        }
    }
    register PCIEPHY_CTRL_466 @0x748 {
    bytes 4;
        field protocol0_ext_tx_ropll_cp_ctl_intg_g1_31_0 {
            bits 32;
            reset 0x0;
            access rw;
        }
    }
    register PCIEPHY_CTRL_467 @0x74C {
    bytes 4;
        field protocol0_ext_tx_ropll_cp_ctl_intg_g1_63_32 {
            bits 32;
            reset 0x0;
            access rw;
        }
    }
    register PCIEPHY_CTRL_468 @0x750 {
    bytes 4;
        field protocol0_ext_tx_ropll_cp_ctl_intg_g1_95_64 {
            bits 32;
            reset 0x0;
            access rw;
        }
    }
    register PCIEPHY_CTRL_469 @0x754 {
    bytes 4;
        field protocol0_ext_tx_ropll_cp_ctl_intg_g2_31_0 {
            bits 32;
            reset 0x0;
            access rw;
        }
    }
    register PCIEPHY_CTRL_470 @0x758 {
    bytes 4;
        field protocol0_ext_tx_ropll_cp_ctl_intg_g2_63_32 {
            bits 32;
            reset 0x0;
            access rw;
        }
    }
    register PCIEPHY_CTRL_471 @0x75C {
    bytes 4;
        field protocol0_ext_tx_ropll_cp_ctl_intg_g2_95_64 {
            bits 32;
            reset 0x0;
            access rw;
        }
    }
    register PCIEPHY_CTRL_472 @0x760 {
    bytes 4;
        field protocol0_ext_tx_ropll_cp_ctl_intg_g3_31_0 {
            bits 32;
            reset 0x0;
            access rw;
        }
    }
    register PCIEPHY_CTRL_473 @0x764 {
    bytes 4;
        field protocol0_ext_tx_ropll_cp_ctl_intg_g3_63_32 {
            bits 32;
            reset 0x0;
            access rw;
        }
    }
    register PCIEPHY_CTRL_474 @0x768 {
    bytes 4;
        field protocol0_ext_tx_ropll_cp_ctl_intg_g3_95_64 {
            bits 32;
            reset 0x0;
            access rw;
        }
    }
    register PCIEPHY_CTRL_475 @0x76C {
    bytes 4;
        field protocol0_ext_tx_ropll_cp_ctl_intg_g4_31_0 {
            bits 32;
            reset 0x0;
            access rw;
        }
    }
    register PCIEPHY_CTRL_476 @0x770 {
    bytes 4;
        field protocol0_ext_tx_ropll_cp_ctl_intg_g4_63_32 {
            bits 32;
            reset 0x0;
            access rw;
        }
    }
    register PCIEPHY_CTRL_477 @0x774 {
    bytes 4;
        field protocol0_ext_tx_ropll_cp_ctl_intg_g4_95_64 {
            bits 32;
            reset 0x0;
            access rw;
        }
    }
    register PCIEPHY_CTRL_478 @0x778 {
    bytes 4;
        field protocol0_ext_tx_ropll_cp_ctl_intg_g5_31_0 {
            bits 32;
            reset 0x0;
            access rw;
        }
    }
    register PCIEPHY_CTRL_479 @0x77C {
    bytes 4;
        field protocol0_ext_tx_ropll_cp_ctl_intg_g5_63_32 {
            bits 32;
            reset 0x0;
            access rw;
        }
    }
    register PCIEPHY_CTRL_480 @0x780 {
    bytes 4;
        field protocol0_ext_tx_ropll_cp_ctl_intg_g5_95_64 {
            bits 32;
            reset 0x0;
            access rw;
        }
    }
    register PCIEPHY_CTRL_481 @0x784 {
    bytes 4;
        field protocol0_ext_tx_ropll_cp_ctl_prop_g1_31_0 {
            bits 32;
            reset 0x0;
            access rw;
        }
    }
    register PCIEPHY_CTRL_482 @0x788 {
    bytes 4;
        field protocol0_ext_tx_ropll_cp_ctl_prop_g1_63_32 {
            bits 32;
            reset 0x0;
            access rw;
        }
    }
    register PCIEPHY_CTRL_483 @0x78C {
    bytes 4;
        field protocol0_ext_tx_ropll_cp_ctl_prop_g1_95_64 {
            bits 32;
            reset 0x0;
            access rw;
        }
    }
    register PCIEPHY_CTRL_484 @0x790 {
    bytes 4;
        field protocol0_ext_tx_ropll_cp_ctl_prop_g2_31_0 {
            bits 32;
            reset 0x0;
            access rw;
        }
    }
    register PCIEPHY_CTRL_485 @0x794 {
    bytes 4;
        field protocol0_ext_tx_ropll_cp_ctl_prop_g2_63_32 {
            bits 32;
            reset 0x0;
            access rw;
        }
    }
    register PCIEPHY_CTRL_486 @0x798 {
    bytes 4;
        field protocol0_ext_tx_ropll_cp_ctl_prop_g2_95_64 {
            bits 32;
            reset 0x0;
            access rw;
        }
    }
    register PCIEPHY_CTRL_487 @0x79C {
    bytes 4;
        field protocol0_ext_tx_ropll_cp_ctl_prop_g3_31_0 {
            bits 32;
            reset 0x0;
            access rw;
        }
    }
    register PCIEPHY_CTRL_488 @0x7A0 {
    bytes 4;
        field protocol0_ext_tx_ropll_cp_ctl_prop_g3_63_32 {
            bits 32;
            reset 0x0;
            access rw;
        }
    }
    register PCIEPHY_CTRL_489 @0x7A4 {
    bytes 4;
        field protocol0_ext_tx_ropll_cp_ctl_prop_g3_95_64 {
            bits 32;
            reset 0x0;
            access rw;
        }
    }
    register PCIEPHY_CTRL_490 @0x7A8 {
    bytes 4;
        field protocol0_ext_tx_ropll_cp_ctl_prop_g4_31_0 {
            bits 32;
            reset 0x0;
            access rw;
        }
    }
    register PCIEPHY_CTRL_491 @0x7AC {
    bytes 4;
        field protocol0_ext_tx_ropll_cp_ctl_prop_g4_63_32 {
            bits 32;
            reset 0x0;
            access rw;
        }
    }
    register PCIEPHY_CTRL_492 @0x7B0 {
    bytes 4;
        field protocol0_ext_tx_ropll_cp_ctl_prop_g4_95_64 {
            bits 32;
            reset 0x0;
            access rw;
        }
    }
    register PCIEPHY_CTRL_493 @0x7B4 {
    bytes 4;
        field protocol0_ext_tx_ropll_cp_ctl_prop_g5_31_0 {
            bits 32;
            reset 0x0;
            access rw;
        }
    }
    register PCIEPHY_CTRL_494 @0x7B8 {
    bytes 4;
        field protocol0_ext_tx_ropll_cp_ctl_prop_g5_63_32 {
            bits 32;
            reset 0x0;
            access rw;
        }
    }
    register PCIEPHY_CTRL_495 @0x7BC {
    bytes 4;
        field protocol0_ext_tx_ropll_cp_ctl_prop_g5_95_64 {
            bits 32;
            reset 0x0;
            access rw;
        }
    }
    register PCIEPHY_CTRL_496 @0x7C0 {
    bytes 4;
        field protocol0_ext_tx_ropll_cp_ctl_intg_g1_111_96 {
            bits 16;
            reset 0x0;
            access rw;
        }
        field protocol0_ext_tx_ropll_cp_ctl_intg_g2_111_96 @ 16 {
            bits 16;
            reset 0x0;
            access rw;
        }
    }
    register PCIEPHY_CTRL_497 @0x7C4 {
    bytes 4;
        field protocol0_ext_tx_ropll_cp_ctl_intg_g3_111_96 {
            bits 16;
            reset 0x0;
            access rw;
        }
        field protocol0_ext_tx_ropll_cp_ctl_intg_g4_111_96 @ 16 {
            bits 16;
            reset 0x0;
            access rw;
        }
    }
    register PCIEPHY_CTRL_498 @0x7C8 {
    bytes 4;
        field protocol0_ext_tx_ropll_cp_ctl_prop_g1_111_96 {
            bits 16;
            reset 0x0;
            access rw;
        }
        field protocol0_ext_tx_ropll_cp_ctl_prop_g2_111_96 @ 16 {
            bits 16;
            reset 0x0;
            access rw;
        }
    }
    register PCIEPHY_CTRL_499 @0x7CC {
    bytes 4;
        field protocol0_ext_tx_ropll_cp_ctl_prop_g3_111_96 {
            bits 16;
            reset 0x0;
            access rw;
        }
        field protocol0_ext_tx_ropll_cp_ctl_prop_g4_111_96 @ 16 {
            bits 16;
            reset 0x0;
            access rw;
        }
    }
    register PCIEPHY_CTRL_500 @0x7D0 {
    bytes 4;
        field protocol0_ext_tx_ropll_cp_ctl_intg_g5_111_96 {
            bits 16;
            reset 0x0;
            access rw;
        }
        field protocol0_ext_tx_ropll_cp_ctl_prop_g5_111_96 @ 16 {
            bits 16;
            reset 0x0;
            access rw;
        }
    }
    register PCIEPHY_CTRL_501 @0x7D4 {
    bytes 4;
        field protocol0_ext_tx_ropll_fbdiv_g1_31_0 {
            bits 32;
            reset 0x0;
            access rw;
        }
    }
    register PCIEPHY_CTRL_502 @0x7D8 {
    bytes 4;
        field protocol0_ext_tx_ropll_fbdiv_g1_63_32 {
            bits 32;
            reset 0x0;
            access rw;
        }
    }
    register PCIEPHY_CTRL_503 @0x7DC {
    bytes 4;
        field protocol0_ext_tx_ropll_fbdiv_g1_95_64 {
            bits 32;
            reset 0x0;
            access rw;
        }
    }
    register PCIEPHY_CTRL_504 @0x7E0 {
    bytes 4;
        field protocol0_ext_tx_ropll_fbdiv_g2_31_0 {
            bits 32;
            reset 0x0;
            access rw;
        }
    }
    register PCIEPHY_CTRL_505 @0x7E4 {
    bytes 4;
        field protocol0_ext_tx_ropll_fbdiv_g2_63_32 {
            bits 32;
            reset 0x0;
            access rw;
        }
    }
    register PCIEPHY_CTRL_506 @0x7E8 {
    bytes 4;
        field protocol0_ext_tx_ropll_fbdiv_g2_95_64 {
            bits 32;
            reset 0x0;
            access rw;
        }
    }
    register PCIEPHY_CTRL_507 @0x7EC {
    bytes 4;
        field protocol0_ext_tx_ropll_fbdiv_g3_31_0 {
            bits 32;
            reset 0x0;
            access rw;
        }
    }
    register PCIEPHY_CTRL_508 @0x7F0 {
    bytes 4;
        field protocol0_ext_tx_ropll_fbdiv_g3_63_32 {
            bits 32;
            reset 0x0;
            access rw;
        }
    }
    register PCIEPHY_CTRL_509 @0x7F4 {
    bytes 4;
        field protocol0_ext_tx_ropll_fbdiv_g3_95_64 {
            bits 32;
            reset 0x0;
            access rw;
        }
    }
    register PCIEPHY_CTRL_510 @0x7F8 {
    bytes 4;
        field protocol0_ext_tx_ropll_fbdiv_g4_31_0 {
            bits 32;
            reset 0x0;
            access rw;
        }
    }
    register PCIEPHY_CTRL_511 @0x7FC {
    bytes 4;
        field protocol0_ext_tx_ropll_fbdiv_g4_63_32 {
            bits 32;
            reset 0x0;
            access rw;
        }
    }
    register PCIEPHY_CTRL_512 @0x800 {
    bytes 4;
        field protocol0_ext_tx_ropll_fbdiv_g4_95_64 {
            bits 32;
            reset 0x0;
            access rw;
        }
    }
    register PCIEPHY_CTRL_513 @0x804 {
    bytes 4;
        field protocol0_ext_tx_ropll_fbdiv_g5_31_0 {
            bits 32;
            reset 0x0;
            access rw;
        }
    }
    register PCIEPHY_CTRL_514 @0x808 {
    bytes 4;
        field protocol0_ext_tx_ropll_fbdiv_g5_63_32 {
            bits 32;
            reset 0x0;
            access rw;
        }
    }
    register PCIEPHY_CTRL_515 @0x80C {
    bytes 4;
        field protocol0_ext_tx_ropll_fbdiv_g5_95_64 {
            bits 32;
            reset 0x0;
            access rw;
        }
    }
    register PCIEPHY_CTRL_516 @0x810 {
    bytes 4;
        field protocol0_ext_tx_ropll_fbdiv_g1_111_96 {
            bits 16;
            reset 0x0;
            access rw;
        }
        field protocol0_ext_tx_ropll_fbdiv_g2_111_96 @ 16 {
            bits 16;
            reset 0x0;
            access rw;
        }
    }
    register PCIEPHY_CTRL_517 @0x814 {
    bytes 4;
        field protocol0_ext_tx_ropll_fbdiv_g3_111_96 {
            bits 16;
            reset 0x0;
            access rw;
        }
        field protocol0_ext_tx_ropll_fbdiv_g4_111_96 @ 16 {
            bits 16;
            reset 0x0;
            access rw;
        }
    }
    register PCIEPHY_CTRL_518 @0x818 {
    bytes 4;
        field protocol0_ext_tx_ropll_fbdiv_g5_111_96 {
            bits 16;
            reset 0x0;
            access rw;
        }
    }
    register PCIEPHY_CTRL_519 @0x81C {
    bytes 4;
        field protocol0_ext_tx_ropll_postdiv_g1_31_0 {
            bits 32;
            reset 0x0;
            access rw;
        }
    }
    register PCIEPHY_CTRL_520 @0x820 {
    bytes 4;
        field protocol0_ext_tx_ropll_postdiv_g2_31_0 {
            bits 32;
            reset 0x0;
            access rw;
        }
    }
    register PCIEPHY_CTRL_521 @0x824 {
    bytes 4;
        field protocol0_ext_tx_ropll_postdiv_g3_31_0 {
            bits 32;
            reset 0x0;
            access rw;
        }
    }
    register PCIEPHY_CTRL_522 @0x828 {
    bytes 4;
        field protocol0_ext_tx_ropll_postdiv_g4_31_0 {
            bits 32;
            reset 0x0;
            access rw;
        }
    }
    register PCIEPHY_CTRL_523 @0x82C {
    bytes 4;
        field protocol0_ext_tx_ropll_postdiv_g5_31_0 {
            bits 32;
            reset 0x0;
            access rw;
        }
    }
    register PCIEPHY_CTRL_524 @0x830 {
    bytes 4;
        field protocol0_ext_tx_ropll_rc_filter_g1_31_0 {
            bits 32;
            reset 0x0;
            access rw;
        }
    }
    register PCIEPHY_CTRL_525 @0x834 {
    bytes 4;
        field protocol0_ext_tx_ropll_rc_filter_g2_31_0 {
            bits 32;
            reset 0x0;
            access rw;
        }
    }
    register PCIEPHY_CTRL_526 @0x838 {
    bytes 4;
        field protocol0_ext_tx_ropll_rc_filter_g3_31_0 {
            bits 32;
            reset 0x0;
            access rw;
        }
    }
    register PCIEPHY_CTRL_527 @0x83C {
    bytes 4;
        field protocol0_ext_tx_ropll_rc_filter_g4_31_0 {
            bits 32;
            reset 0x0;
            access rw;
        }
    }
    register PCIEPHY_CTRL_528 @0x840 {
    bytes 4;
        field protocol0_ext_tx_ropll_rc_filter_g5_31_0 {
            bits 32;
            reset 0x0;
            access rw;
        }
    }
    register PCIEPHY_CTRL_529 @0x844 {
    bytes 4;
        field protocol0_ext_tx_ropll_postdiv_g1_47_32 {
            bits 16;
            reset 0x0;
            access rw;
        }
        field protocol0_ext_tx_ropll_postdiv_g2_47_32 @ 16 {
            bits 16;
            reset 0x0;
            access rw;
        }
    }
    register PCIEPHY_CTRL_530 @0x848 {
    bytes 4;
        field protocol0_ext_tx_ropll_postdiv_g3_47_32 {
            bits 16;
            reset 0x0;
            access rw;
        }
        field protocol0_ext_tx_ropll_postdiv_g4_47_32 @ 16 {
            bits 16;
            reset 0x0;
            access rw;
        }
    }
    register PCIEPHY_CTRL_531 @0x84C {
    bytes 4;
        field protocol0_ext_tx_ropll_rc_filter_g1_47_32 {
            bits 16;
            reset 0x0;
            access rw;
        }
        field protocol0_ext_tx_ropll_rc_filter_g2_47_32 @ 16 {
            bits 16;
            reset 0x0;
            access rw;
        }
    }
    register PCIEPHY_CTRL_532 @0x850 {
    bytes 4;
        field protocol0_ext_tx_ropll_rc_filter_g3_47_32 {
            bits 16;
            reset 0x0;
            access rw;
        }
        field protocol0_ext_tx_ropll_rc_filter_g4_47_32 @ 16 {
            bits 16;
            reset 0x0;
            access rw;
        }
    }
    register PCIEPHY_CTRL_533 @0x854 {
    bytes 4;
        field protocol0_ext_tx_ropll_postdiv_g5_47_32 {
            bits 16;
            reset 0x0;
            access rw;
        }
        field protocol0_ext_tx_ropll_rc_filter_g5_47_32 @ 16 {
            bits 16;
            reset 0x0;
            access rw;
        }
    }
    register PCIEPHY_CTRL_534 @0x858 {
    bytes 4;
        field protocol0_ext_tx_ropll_refdiv_g1_31_0 {
            bits 32;
            reset 0x0;
            access rw;
        }
    }
    register PCIEPHY_CTRL_535 @0x85C {
    bytes 4;
        field protocol0_ext_tx_ropll_refdiv_g1_63_32 {
            bits 32;
            reset 0x0;
            access rw;
        }
    }
    register PCIEPHY_CTRL_536 @0x860 {
    bytes 4;
        field protocol0_ext_tx_ropll_refdiv_g2_31_0 {
            bits 32;
            reset 0x0;
            access rw;
        }
    }
    register PCIEPHY_CTRL_537 @0x864 {
    bytes 4;
        field protocol0_ext_tx_ropll_refdiv_g2_63_32 {
            bits 32;
            reset 0x0;
            access rw;
        }
    }
    register PCIEPHY_CTRL_538 @0x868 {
    bytes 4;
        field protocol0_ext_tx_ropll_refdiv_g3_31_0 {
            bits 32;
            reset 0x0;
            access rw;
        }
    }
    register PCIEPHY_CTRL_539 @0x86C {
    bytes 4;
        field protocol0_ext_tx_ropll_refdiv_g3_63_32 {
            bits 32;
            reset 0x0;
            access rw;
        }
    }
    register PCIEPHY_CTRL_540 @0x870 {
    bytes 4;
        field protocol0_ext_tx_ropll_refdiv_g4_31_0 {
            bits 32;
            reset 0x0;
            access rw;
        }
    }
    register PCIEPHY_CTRL_541 @0x874 {
    bytes 4;
        field protocol0_ext_tx_ropll_refdiv_g4_63_32 {
            bits 32;
            reset 0x0;
            access rw;
        }
    }
    register PCIEPHY_CTRL_542 @0x878 {
    bytes 4;
        field protocol0_ext_tx_ropll_refdiv_g5_31_0 {
            bits 32;
            reset 0x0;
            access rw;
        }
    }
    register PCIEPHY_CTRL_543 @0x87C {
    bytes 4;
        field protocol0_ext_tx_ropll_refdiv_g5_63_32 {
            bits 32;
            reset 0x0;
            access rw;
        }
    }
    register PCIEPHY_CTRL_544 @0x880 {
    bytes 4;
        field protocol0_ext_tx_ropll_refsel_g1 {
            bits 32;
            reset 0x0;
            access rw;
        }
    }
    register PCIEPHY_CTRL_545 @0x884 {
    bytes 4;
        field protocol0_ext_tx_ropll_refsel_g2 {
            bits 32;
            reset 0x0;
            access rw;
        }
    }
    register PCIEPHY_CTRL_546 @0x888 {
    bytes 4;
        field protocol0_ext_tx_ropll_refsel_g3 {
            bits 32;
            reset 0x0;
            access rw;
        }
    }
    register PCIEPHY_CTRL_547 @0x88C {
    bytes 4;
        field protocol0_ext_tx_ropll_refsel_g4 {
            bits 32;
            reset 0x0;
            access rw;
        }
    }
    register PCIEPHY_CTRL_548 @0x890 {
    bytes 4;
        field protocol0_ext_tx_ropll_refsel_g5 {
            bits 32;
            reset 0x0;
            access rw;
        }
    }
    register PCIEPHY_CTRL_549 @0x894 {
    bytes 4;
        field protocol0_ext_tx_ropll_v2i_mode_g1 {
            bits 32;
            reset 0x0;
            access rw;
        }
    }
    register PCIEPHY_CTRL_550 @0x898 {
    bytes 4;
        field protocol0_ext_tx_ropll_v2i_mode_g2 {
            bits 32;
            reset 0x0;
            access rw;
        }
    }
    register PCIEPHY_CTRL_551 @0x89C {
    bytes 4;
        field protocol0_ext_tx_ropll_v2i_mode_g3 {
            bits 32;
            reset 0x0;
            access rw;
        }
    }
    register PCIEPHY_CTRL_552 @0x8A0 {
    bytes 4;
        field protocol0_ext_tx_ropll_v2i_mode_g4 {
            bits 32;
            reset 0x0;
            access rw;
        }
    }
    register PCIEPHY_CTRL_553 @0x8A4 {
    bytes 4;
        field protocol0_ext_tx_ropll_v2i_mode_g5 {
            bits 32;
            reset 0x0;
            access rw;
        }
    }
    register PCIEPHY_CTRL_554 @0x8A8 {
    bytes 4;
        field protocol0_ext_tx_ropll_vco_low_freq_g1 {
            bits 32;
            reset 0x0;
            access rw;
        }
    }
    register PCIEPHY_CTRL_555 @0x8AC {
    bytes 4;
        field protocol0_ext_tx_ropll_vco_low_freq_g2 {
            bits 32;
            reset 0x0;
            access rw;
        }
    }
    register PCIEPHY_CTRL_556 @0x8B0 {
    bytes 4;
        field protocol0_ext_tx_ropll_vco_low_freq_g3 {
            bits 32;
            reset 0x0;
            access rw;
        }
    }
    register PCIEPHY_CTRL_557 @0x8B4 {
    bytes 4;
        field protocol0_ext_tx_ropll_vco_low_freq_g4 {
            bits 32;
            reset 0x0;
            access rw;
        }
    }
    register PCIEPHY_CTRL_558 @0x8B8 {
    bytes 4;
        field protocol0_ext_tx_ropll_vco_low_freq_g5 {
            bits 32;
            reset 0x0;
            access rw;
        }
    }
    register PCIEPHY_CTRL_559 @0x8BC {
    bytes 4;
        field protocol0_ext_tx_ropll_word_clk_div_sel_g1 {
            bits 32;
            reset 0x0;
            access rw;
        }
    }
    register PCIEPHY_CTRL_560 @0x8C0 {
    bytes 4;
        field protocol0_ext_tx_ropll_word_clk_div_sel_g2 {
            bits 32;
            reset 0x0;
            access rw;
        }
    }
    register PCIEPHY_CTRL_561 @0x8C4 {
    bytes 4;
        field protocol0_ext_tx_ropll_word_clk_div_sel_g3 {
            bits 32;
            reset 0x0;
            access rw;
        }
    }
    register PCIEPHY_CTRL_562 @0x8C8 {
    bytes 4;
        field protocol0_ext_tx_ropll_word_clk_div_sel_g4 {
            bits 32;
            reset 0x0;
            access rw;
        }
    }
    register PCIEPHY_CTRL_563 @0x8CC {
    bytes 4;
        field protocol0_ext_tx_ropll_word_clk_div_sel_g5 {
            bits 32;
            reset 0x0;
            access rw;
        }
    }
    register PCIEPHY_CTRL_564 @0x8D0 {
    bytes 4;
        field protocol0_ext_tx_term_ctrl_g1 {
            bits 4;
            reset 0x0;
            access rw;
        }
        field protocol0_ext_tx_term_ctrl_g2 @ 4 {
            bits 4;
            reset 0x0;
            access rw;
        }
        field protocol0_ext_tx_term_ctrl_g3 @ 8 {
            bits 4;
            reset 0x0;
            access rw;
        }
        field protocol0_ext_tx_term_ctrl_g4 @ 12 {
            bits 4;
            reset 0x0;
            access rw;
        }
        field protocol0_ext_tx_term_ctrl_g5 @ 16 {
            bits 4;
            reset 0x0;
            access rw;
        }
    }
    register PCIEPHY_CTRL_565 @0x8D4 {
    bytes 4;
        field phy0_sram_ded_sticky_status {
            bits 1;
            reset 0x0;
            access ro;
        }
        field phy0_sram_sec_sticky_status @ 1 {
            bits 1;
            reset 0x0;
            access ro;
        }
        field phy0_mplla_force_ack @ 2 {
            bits 1;
            reset 0x0;
            access ro;
        }
        field phy0_mplla_state @ 3 {
            bits 1;
            reset 0x0;
            access ro;
        }
        field phy0_mpllb_force_ack @ 4 {
            bits 1;
            reset 0x0;
            access ro;
        }
        field phy0_mpllb_state @ 5 {
            bits 1;
            reset 0x0;
            access ro;
        }
        field phy0_refa_clkdet_result @ 6 {
            bits 1;
            reset 0x0;
            access ro;
        }
        field phy0_refb_clkdet_result @ 7 {
            bits 1;
            reset 0x0;
            access ro;
        }
    }
    register PCIEPHY_CTRL_566 @0x8D8 {
    bytes 4;
        field phy0_sram_init_done {
            bits 1;
            reset 0x0;
            access ro;
        }
    }
    register PCIEPHY_CTRL_567 @0x8DC {
    bytes 4;
        field phy1_sram_ded_sticky_status {
            bits 1;
            reset 0x0;
            access ro;
        }
        field phy1_sram_sec_sticky_status @ 1 {
            bits 1;
            reset 0x0;
            access ro;
        }
        field phy1_mplla_force_ack @ 2 {
            bits 1;
            reset 0x0;
            access ro;
        }
        field phy1_mplla_state @ 3 {
            bits 1;
            reset 0x0;
            access ro;
        }
        field phy1_mpllb_force_ack @ 4 {
            bits 1;
            reset 0x0;
            access ro;
        }
        field phy1_mpllb_state @ 5 {
            bits 1;
            reset 0x0;
            access ro;
        }
        field phy1_refa_clkdet_result @ 6 {
            bits 1;
            reset 0x0;
            access ro;
        }
        field phy1_refb_clkdet_result @ 7 {
            bits 1;
            reset 0x0;
            access ro;
        }
    }
    register PCIEPHY_CTRL_568 @0x8E0 {
    bytes 4;
        field phy1_sram_init_done {
            bits 1;
            reset 0x0;
            access ro;
        }
    }
    register PCIEPHY_CTRL_569 @0x8E4 {
    bytes 4;
        field phy2_sram_ded_sticky_status {
            bits 1;
            reset 0x0;
            access ro;
        }
        field phy2_sram_sec_sticky_status @ 1 {
            bits 1;
            reset 0x0;
            access ro;
        }
        field phy2_mplla_force_ack @ 2 {
            bits 1;
            reset 0x0;
            access ro;
        }
        field phy2_mplla_state @ 3 {
            bits 1;
            reset 0x0;
            access ro;
        }
        field phy2_mpllb_force_ack @ 4 {
            bits 1;
            reset 0x0;
            access ro;
        }
        field phy2_mpllb_state @ 5 {
            bits 1;
            reset 0x0;
            access ro;
        }
        field phy2_refa_clkdet_result @ 6 {
            bits 1;
            reset 0x0;
            access ro;
        }
        field phy2_refb_clkdet_result @ 7 {
            bits 1;
            reset 0x0;
            access ro;
        }
    }
    register PCIEPHY_CTRL_570 @0x8E8 {
    bytes 4;
        field phy2_sram_init_done {
            bits 1;
            reset 0x0;
            access ro;
        }
    }
    register PCIEPHY_CTRL_571 @0x8EC {
    bytes 4;
        field phy3_sram_ded_sticky_status {
            bits 1;
            reset 0x0;
            access ro;
        }
        field phy3_sram_sec_sticky_status @ 1 {
            bits 1;
            reset 0x0;
            access ro;
        }
        field phy3_mplla_force_ack @ 2 {
            bits 1;
            reset 0x0;
            access ro;
        }
        field phy3_mplla_state @ 3 {
            bits 1;
            reset 0x0;
            access ro;
        }
        field phy3_mpllb_force_ack @ 4 {
            bits 1;
            reset 0x0;
            access ro;
        }
        field phy3_mpllb_state @ 5 {
            bits 1;
            reset 0x0;
            access ro;
        }
        field phy3_refa_clkdet_result @ 6 {
            bits 1;
            reset 0x0;
            access ro;
        }
        field phy3_refb_clkdet_result @ 7 {
            bits 1;
            reset 0x0;
            access ro;
        }
    }
    register PCIEPHY_CTRL_572 @0x8F0 {
    bytes 4;
        field phy3_sram_init_done {
            bits 1;
            reset 0x0;
            access ro;
        }
    }
    register PCIEPHY_CTRL_573 @0x8F4 {
    bytes 4;
        field phy_rx0_ppm_drift {
            bits 6;
            reset 0x1;
            access ro;
        }
    }
    register PCIEPHY_CTRL_574 @0x8F8 {
    bytes 4;
        field phy_rx1_ppm_drift {
            bits 6;
            reset 0x1;
            access ro;
        }
    }
    register PCIEPHY_CTRL_575 @0x8FC {
    bytes 4;
        field phy_rx2_ppm_drift {
            bits 6;
            reset 0x1;
            access ro;
        }
    }
    register PCIEPHY_CTRL_576 @0x900 {
    bytes 4;
        field phy_rx3_ppm_drift {
            bits 6;
            reset 0x1;
            access ro;
        }
    }
    register PCIEPHY_CTRL_577 @0x904 {
    bytes 4;
        field phy_rx4_ppm_drift {
            bits 6;
            reset 0x1;
            access ro;
        }
    }
    register PCIEPHY_CTRL_578 @0x908 {
    bytes 4;
        field phy_rx5_ppm_drift {
            bits 6;
            reset 0x1;
            access ro;
        }
    }
    register PCIEPHY_CTRL_579 @0x90C {
    bytes 4;
        field phy_rx6_ppm_drift {
            bits 6;
            reset 0x1;
            access ro;
        }
    }
    register PCIEPHY_CTRL_580 @0x910 {
    bytes 4;
        field phy_rx7_ppm_drift {
            bits 6;
            reset 0x1;
            access ro;
        }
    }
    register PCIEPHY_CTRL_581 @0x914 {
    bytes 4;
        field phy_rx8_ppm_drift {
            bits 6;
            reset 0x1;
            access ro;
        }
    }
    register PCIEPHY_CTRL_582 @0x918 {
    bytes 4;
        field phy_rx9_ppm_drift {
            bits 6;
            reset 0x1;
            access ro;
        }
    }
    register PCIEPHY_CTRL_583 @0x91C {
    bytes 4;
        field phy_rx10_ppm_drift {
            bits 6;
            reset 0x1;
            access ro;
        }
    }
    register PCIEPHY_CTRL_584 @0x920 {
    bytes 4;
        field phy_rx11_ppm_drift {
            bits 6;
            reset 0x1;
            access ro;
        }
    }
    register PCIEPHY_CTRL_585 @0x924 {
    bytes 4;
        field phy_rx12_ppm_drift {
            bits 6;
            reset 0x1;
            access ro;
        }
    }
    register PCIEPHY_CTRL_586 @0x928 {
    bytes 4;
        field phy_rx13_ppm_drift {
            bits 6;
            reset 0x1;
            access ro;
        }
    }
    register PCIEPHY_CTRL_587 @0x92C {
    bytes 4;
        field phy_rx14_ppm_drift {
            bits 6;
            reset 0x1;
            access ro;
        }
    }
    register PCIEPHY_CTRL_588 @0x930 {
    bytes 4;
        field phy_rx15_ppm_drift {
            bits 6;
            reset 0x1;
            access ro;
        }
    }
    register PCIEPHY_CTRL_589 @0x934 {
    bytes 4;
        field upcs_max_payload_size_supt {
            bits 3;
            reset 0x5;
            access ro;
        }
    }
}
